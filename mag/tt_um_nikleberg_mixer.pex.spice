* NGSPICE file created from tt_um_nikleberg_mixer.ext - technology: ihp-sg13g2

.subckt st_1v1 A VSS Y a_142_n594# VDD a_142_n38#
X0 a_142_n38# Y VSS.t2 VDD sg13_lv_pmos ad=0.204p pd=1.88u as=0.204p ps=1.88u w=0.6u l=0.13u
X1 Y A a_142_n38# VDD sg13_lv_pmos ad=0.204p pd=1.88u as=0.114p ps=0.98u w=0.6u l=0.13u
X2 a_142_n594# A VSS VSS.t0 sg13_lv_nmos ad=0.114p pd=0.98u as=0.204p ps=1.88u w=0.6u l=0.13u
X3 VDD Y a_142_n594# VSS.t3 sg13_lv_nmos ad=0.204p pd=1.88u as=0.204p ps=1.88u w=0.6u l=0.13u
X4 Y A a_142_n594# VSS.t1 sg13_lv_nmos ad=0.204p pd=1.88u as=0.114p ps=0.98u w=0.6u l=0.13u
X5 a_142_n38# A VDD VDD sg13_lv_pmos ad=0.114p pd=0.98u as=0.204p ps=1.88u w=0.6u l=0.13u
R0 VSS.n1 VSS.t0 666.129
R1 VSS.t0 VSS.t3 212.429
R2 VSS.t3 VSS.t1 9.2
R3 VSS VSS.t2 1.98121
R4 VSS.n1 VSS.n0 0.39753
R5 VSS VSS.n0 1.05939
R6 VSS.t2 VSS.n0 1.26213
R7 VSS.n1 VSS.t1 1.59319
C0 Y VDD 0.29535f
C1 VDD a_142_n594# 0.04429f
C2 Y A 0.07738f
C3 A a_142_n594# 0.06569f
C4 a_142_n38# VDD 0.06239f
C5 Y a_142_n594# 0.08992f
C6 a_142_n38# A 0.06569f
C7 a_142_n38# Y 0.08992f
C8 A VDD 0.58215f
C9 a_142_n594# VSS 0.27643f
C10 a_142_n38# VSS 0.76349f
C11 VDD VSS 0.7905f
C12 VSS.t2 VSS 0.28935f
.ends

.subckt st_4v1 A VSS Y a_142_n594# VDD a_142_n38#
X0 a_142_n38# Y VSS.t0 VDD sg13_lv_pmos ad=0.204p pd=1.88u as=0.204p ps=1.88u w=0.6u l=0.13u
X1 Y A a_142_n38# VDD sg13_lv_pmos ad=0.816p pd=5.48u as=0.456p ps=2.78u w=2.4u l=0.13u
X2 VDD Y a_142_n594# VSS.t1 sg13_lv_nmos ad=0.204p pd=1.88u as=0.204p ps=1.88u w=0.6u l=0.13u
X3 a_142_n594# A VSS.t3 VSS.t2 sg13_lv_nmos ad=0.456p pd=2.78u as=0.816p ps=5.48u w=2.4u l=0.13u
X4 a_142_n38# A VDD VDD sg13_lv_pmos ad=0.456p pd=2.78u as=0.816p ps=5.48u w=2.4u l=0.13u
X5 Y A a_142_n594# VSS.t4 sg13_lv_nmos ad=0.816p pd=5.48u as=0.456p ps=2.78u w=2.4u l=0.13u
R0 VSS.n2 VSS.t2 437.858
R1 VSS.t2 VSS.t1 139.734
R2 VSS.t1 VSS.t4 6.23253
R3 VSS.n0 VSS.n2 0.160371
R4 VSS.n1 VSS.t3 2.42907
R5 VSS.n0 VSS.t0 1.54961
R6 VSS.n2 VSS.t4 1.59093
R7 VSS.n0 VSS.n1 0.880425
R8 VSS VSS.n1 1.14251
R9 VSS VSS.t0 1.01184
C0 Y a_142_n594# 0.22595f
C1 Y VDD 0.4171f
C2 Y A 0.11155f
C3 Y a_142_n38# 0.22595f
C4 a_142_n594# VDD 0.04956f
C5 a_142_n594# A 0.10157f
C6 A VDD 0.71695f
C7 VDD a_142_n38# 0.19842f
C8 A a_142_n38# 0.10157f
C9 a_142_n594# VSS 0.49316f
C10 a_142_n38# VSS 0.98126f
C11 VDD VSS 0.96705f
C12 VSS.t0 VSS 0.34052f
.ends

.subckt r2r B a_2302_n400# a_1910_n400# Vb6 Vb5 a_n1814_n486# a_1518_400# a_930_n400#
+ a_146_n400# Vb4 Vb3 Vb1 Vb2 a_n246_n400# a_2106_n486# a_1714_n486# Vb0 a_n1618_n400#
+ a_1126_400# Vout a_1518_n400# a_n50_n400# a_n1422_n400# a_538_n400# a_1322_n400#
+ a_n50_400# a_342_n400# a_n638_n400# a_n2402_400# a_342_400# a_n442_n400# a_n1814_n400#
+ a_n2206_n400# a_n2010_400# a_930_n486# a_2106_n400# a_1714_n400# a_n2010_n400# a_n246_n486#
+ a_734_n400# a_n1422_n486# a_n2598_n400# a_n834_n400# a_538_n486# a_n1226_400# a_2498_n400#
+ a_n1226_n400# a_n2402_n400# a_n638_n486# a_1126_n400# a_n834_400# a_n1030_n400#
+ Vb7
X0 a_n2010_400# Vout B.t6 rhigh l=4u w=0.5u
X1 a_n1226_400# Vb5 B.t27 rhigh l=4u w=0.5u
X2 a_1126_400# Vb1 B.t21 rhigh l=4u w=0.5u
X3 a_n2402_400# Vb7 B.t2 rhigh l=4u w=0.5u
X4 B.t14 a_2106_n486# B.t13 rhigh l=4u w=0.5u
X5 a_n50_400# Vb3 B rhigh l=4u w=0.5u
X6 a_n834_400# a_n1422_n486# B.t11 rhigh l=4u w=0.5u
X7 a_342_400# a_538_n486# B.t10 rhigh l=4u w=0.5u
X8 a_n834_400# a_n638_n486# B.t24 rhigh l=4u w=0.5u
X9 Vb6 a_n1814_n486# B.t3 rhigh l=4u w=0.5u
X10 Vb0 a_1714_n486# B.t15 rhigh l=4u w=0.5u
X11 a_342_400# a_n246_n486# B.t25 rhigh l=4u w=0.5u
X12 a_n1226_400# a_n1422_n486# B.t7 rhigh l=4u w=0.5u
X13 a_n2402_400# Vout B.t4 rhigh l=4u w=0.5u
X14 a_1518_400# a_2106_n486# B.t26 rhigh l=4u w=0.5u
X15 a_n2010_400# a_n1422_n486# B.t20 rhigh l=4u w=0.5u
X16 a_1126_400# a_930_n486# B.t9 rhigh l=4u w=0.5u
X17 B.t1 B.t1 B.t0 rhigh l=4u w=0.5u
X18 B.t14 B.t14 B.t16 rhigh l=4u w=0.5u
X19 Vb4 a_n638_n486# B.t8 rhigh l=4u w=0.5u
X20 Vb2 a_538_n486# B.t12 rhigh l=4u w=0.5u
X21 a_342_400# a_930_n486# B.t18 rhigh l=4u w=0.5u
X22 a_n834_400# a_n246_n486# B.t17 rhigh l=4u w=0.5u
X23 a_n2010_400# a_n1814_n486# B.t5 rhigh l=4u w=0.5u
X24 a_1518_400# a_930_n486# B.t22 rhigh l=4u w=0.5u
X25 a_n50_400# a_n246_n486# B.t19 rhigh l=4u w=0.5u
X26 a_1518_400# a_1714_n486# B.t23 rhigh l=4u w=0.5u
R0 B.t2 B.t0 426.087
R1 B.t4 B.t2 426.087
R2 B.t6 B.t4 426.087
R3 B.t3 B.t6 426.087
R4 B.t5 B.t3 426.087
R5 B.t20 B.t5 426.087
R6 B.t27 B.t20 426.087
R7 B.t7 B.t27 426.087
R8 B.t11 B.t7 426.087
R9 B.t8 B.t11 426.087
R10 B.t24 B.t8 426.087
R11 B.t17 B.t24 426.087
R12 B B.t17 426.087
R13 B.t19 B 426.087
R14 B.t25 B.t19 426.087
R15 B.t12 B.t25 426.087
R16 B.t10 B.t12 426.087
R17 B.t18 B.t10 426.087
R18 B.t21 B.t18 426.087
R19 B.t9 B.t21 426.087
R20 B.t22 B.t9 426.087
R21 B.t15 B.t22 426.087
R22 B.t23 B.t15 426.087
R23 B.t26 B.t23 426.087
R24 B.t13 B.t26 426.087
R25 B.t16 B.t13 426.087
R26 B B.t0 353.236
R27 B B.t16 353.236
R28 B B.t14 1.28118
R29 B B.t1 1.18643
C0 a_342_n400# a_n246_n486# 0.0245f
C1 Vb3 a_n834_400# 0.01184f
C2 a_538_n486# a_n246_n486# 0.01589f
C3 a_n1422_n486# a_n1814_n400# 0.0016f
C4 a_930_n486# a_2106_n400# 0
C5 a_n1030_n400# Vb3 0.0032f
C6 Vb3 a_1126_400# 0
C7 Vout a_n1814_n486# 0.02235f
C8 a_n638_n486# a_n834_400# 0.00606f
C9 a_n50_n400# Vb5 0
C10 a_342_n400# a_930_n486# 0
C11 a_146_n400# a_n50_n400# 0.05097f
C12 a_1322_n400# a_1518_400# 0.00569f
C13 a_146_n400# a_342_400# 0.00569f
C14 a_1518_400# Vb0 0.07821f
C15 a_930_n486# a_538_n486# 0.01678f
C16 Vb3 Vb4 0.01204f
C17 a_1518_400# a_930_n400# 0
C18 a_n1814_n400# a_n2010_n400# 0.05097f
C19 a_930_n486# a_2498_n400# 0
C20 Vb3 a_n246_n486# 0.12443f
C21 a_n834_n400# Vb5 0.01204f
C22 a_n442_n400# Vb3 0.01204f
C23 a_342_n400# a_538_n400# 0.05097f
C24 a_n1422_n400# Vb5 0.01859f
C25 Vb1 Vb2 0.01204f
C26 a_538_n400# a_538_n486# 0.0188f
C27 Vb5 a_n834_400# 0.00625f
C28 a_n638_n486# Vb4 0
C29 a_1518_400# a_2106_n400# 0.02482f
C30 a_146_n400# a_n834_400# 0
C31 a_n834_n400# a_n2010_400# 0
C32 a_n1814_n400# Vb6 0.01501f
C33 Vb1 a_1714_n400# 0.00775f
C34 a_n638_n486# a_n246_n486# 0.01678f
C35 a_n1422_n400# a_n2010_400# 0.0245f
C36 a_n1422_n486# a_n246_n400# 0
C37 a_n1030_n400# Vb5 0.01859f
C38 a_n2010_400# a_n834_400# 0.00278f
C39 a_n442_n400# a_n638_n486# 0.0188f
C40 a_n1422_n486# a_n1226_400# 0.00606f
C41 Vb1 a_2106_n486# 0
C42 a_930_n486# Vb3 0
C43 a_n1422_n400# a_n1226_n400# 0.05097f
C44 a_734_n400# a_342_400# 0.04561f
C45 a_n1226_n400# a_n834_400# 0.0016f
C46 a_n834_n400# a_n638_n400# 0.05097f
C47 a_1518_400# a_2498_n400# 0
C48 a_n1618_n400# a_n1814_n486# 0.0188f
C49 a_n1030_n400# a_n2010_400# 0
C50 a_n1422_n486# a_n2010_n400# 0
C51 Vb5 Vb4 0.01204f
C52 a_n638_n400# a_n834_400# 0.05016f
C53 a_n1030_n400# a_n1226_n400# 0.05097f
C54 a_538_n400# Vb3 0.00775f
C55 Vb7 a_n2402_400# 0.04212f
C56 Vb5 a_n246_n486# 0
C57 a_146_n400# a_n246_n486# 0.04561f
C58 a_n442_n400# Vb5 0.00471f
C59 a_n1814_n400# a_n1814_n486# 0.0188f
C60 a_n638_n400# Vb4 0.01501f
C61 a_n1226_400# Vb6 0
C62 a_930_n486# a_146_n400# 0
C63 a_n638_n400# a_n246_n486# 0.0016f
C64 a_n442_n400# a_n638_n400# 0.05097f
C65 a_734_n400# a_n246_n486# 0
C66 a_n50_400# a_n50_n400# 0.0188f
C67 a_n50_400# a_342_400# 0.01678f
C68 a_930_n400# Vb3 0.0032f
C69 a_n1422_n486# a_n1814_n486# 0.01678f
C70 a_930_n486# a_734_n400# 0.00569f
C71 a_n50_400# a_n834_400# 0.01589f
C72 a_1714_n486# Vb1 0.00146f
C73 a_1714_n486# a_1714_n400# 0.0188f
C74 a_n1422_n486# a_n2402_n400# 0
C75 a_342_n400# Vb3 0.01204f
C76 a_n1618_n400# a_n1422_n400# 0.05097f
C77 a_1714_n486# a_2106_n486# 0.01549f
C78 a_n1618_n400# a_n834_400# 0
C79 a_538_n400# a_734_n400# 0.05097f
C80 a_538_n486# Vb3 0.00146f
C81 a_n50_400# Vb4 0
C82 Vb7 Vb5 0.01536f
C83 Vb6 a_n1814_n486# 0
C84 a_1518_400# a_734_n400# 0
C85 Vb7 a_n2206_n400# 0.02128f
C86 a_n50_400# a_n246_n486# 0.00606f
C87 Vb7 a_n2010_400# 0.00625f
C88 Vb7 a_n2598_n400# 0
C89 Vb1 a_1910_n400# 0.00471f
C90 a_930_n486# a_2302_n400# 0
C91 Vb7 a_n1226_n400# 0
C92 a_1714_n400# a_1910_n400# 0.05097f
C93 a_n2402_400# Vb5 0
C94 Vb2 a_342_400# 0.07821f
C95 Vb1 a_1126_n400# 0.0496f
C96 Vb1 a_n50_n400# 0
C97 a_n2402_400# a_n2206_n400# 0.01914f
C98 Vb1 a_342_400# 0.01184f
C99 a_342_n400# a_146_n400# 0.05097f
C100 a_n246_n400# a_n50_n400# 0.05097f
C101 a_n2402_400# a_n2010_400# 0.01678f
C102 a_n246_n400# a_342_400# 0
C103 Vb1 a_1518_n400# 0.01204f
C104 a_930_n400# a_734_n400# 0.05097f
C105 a_1714_n400# a_1518_n400# 0.05097f
C106 a_n638_n486# Vb3 0.00279f
C107 a_n1422_n486# a_n834_n400# 0.0245f
C108 a_n1422_n486# a_n1422_n400# 0.04482f
C109 a_2302_n400# a_1518_400# 0.0016f
C110 a_n1422_n486# a_n834_400# 0.00197f
C111 a_n246_n400# a_n834_400# 0.0245f
C112 Vb2 a_1126_400# 0
C113 a_n1226_400# a_n834_400# 0.01678f
C114 Vb7 Vout 0.03276f
C115 a_n1422_n486# a_n1030_n400# 0.04561f
C116 Vb1 a_1126_400# 0.04014f
C117 Vb3 Vb5 0.01692f
C118 a_146_n400# Vb3 0.01859f
C119 a_538_n486# a_734_n400# 0.0188f
C120 a_n1030_n400# a_n1226_400# 0.0188f
C121 a_n2402_400# Vout 0.00205f
C122 Vb3 a_n1226_n400# 0
C123 a_n638_n486# Vb5 0.00146f
C124 a_n1422_n486# a_n246_n486# 0.00278f
C125 Vb1 a_n246_n486# 0.00125f
C126 a_n1226_400# Vb4 0.00206f
C127 a_n246_n400# a_n246_n486# 0.04482f
C128 a_n1422_n486# a_n442_n400# 0
C129 Vb3 a_n638_n400# 0.00775f
C130 a_n442_n400# a_n246_n400# 0.05097f
C131 a_2302_n400# a_2106_n400# 0.05097f
C132 Vb3 a_734_n400# 0.00471f
C133 Vb1 a_930_n486# 0.12443f
C134 a_1714_n486# a_1910_n400# 0.0188f
C135 a_n638_n486# a_n638_n400# 0.0188f
C136 a_n1618_n400# Vb7 0.00471f
C137 a_930_n486# a_1714_n400# 0.0016f
C138 a_n2206_n400# Vb5 0.00366f
C139 a_2106_n486# a_930_n486# 0
C140 a_2302_n400# a_2498_n400# 0.05097f
C141 a_538_n400# Vb2 0.01501f
C142 a_n2010_400# Vb5 0.01184f
C143 a_n1226_n400# Vb5 0.0496f
C144 Vb1 a_538_n400# 0.00775f
C145 a_n2010_400# a_n2206_n400# 0.00569f
C146 Vb7 a_n1814_n400# 0.00775f
C147 a_n638_n400# Vb5 0.00775f
C148 a_n2010_400# a_n2598_n400# 0
C149 a_n2010_400# a_n1226_n400# 0.0016f
C150 Vb1 a_1518_400# 0.00625f
C151 a_n638_n486# Vout 0
C152 a_1714_n400# a_1518_400# 0.05016f
C153 a_2106_n486# a_1518_400# 0.00171f
C154 a_n50_400# Vb3 0.04014f
C155 Vb5 Vout 0.00252f
C156 Vb1 a_1322_n400# 0.01859f
C157 a_n1422_n486# Vb7 0
C158 Vb1 Vb0 0.01204f
C159 a_1126_n400# a_342_400# 0.0016f
C160 a_n50_n400# a_342_400# 0.0016f
C161 a_1714_n400# Vb0 0.01501f
C162 Vb1 a_930_n400# 0.01859f
C163 a_n2206_n400# Vout 0.03107f
C164 Vb7 a_n1226_400# 0
C165 a_n2010_400# Vout 0.00268f
C166 a_1518_n400# a_342_400# 0
C167 Vb7 a_n2010_n400# 0.01204f
C168 Vb1 a_2106_n400# 0.00366f
C169 a_n50_n400# a_n834_400# 0.0016f
C170 a_342_400# a_n834_400# 0.00278f
C171 Vb2 a_538_n486# 0
C172 a_2106_n486# a_2106_n400# 0.01914f
C173 Vb1 a_342_n400# 0.00471f
C174 a_n50_400# Vb5 0
C175 a_1714_n486# a_930_n486# 0.01589f
C176 Vb1 a_538_n486# 0.00279f
C177 a_n50_400# a_146_n400# 0.0188f
C178 a_1126_n400# a_1126_400# 0.0188f
C179 a_n834_n400# a_n834_400# 0.04482f
C180 a_1126_400# a_342_400# 0.01589f
C181 Vb1 a_2498_n400# 0
C182 Vb7 Vb6 0.01204f
C183 a_n1422_n400# a_n834_400# 0
C184 a_n1618_n400# Vb5 0.01204f
C185 a_n834_n400# a_n1030_n400# 0.05097f
C186 a_n50_n400# a_n246_n486# 0.05016f
C187 a_n1030_n400# a_n834_400# 0.00569f
C188 Vb2 Vb3 0.01204f
C189 a_342_400# a_n246_n486# 0.00197f
C190 a_n1618_n400# a_n2010_400# 0.04561f
C191 a_n2402_400# Vb6 0.00206f
C192 a_n442_n400# a_342_400# 0
C193 a_1714_n486# a_1518_400# 0.00606f
C194 a_n1422_n486# Vb3 0.00125f
C195 Vb1 Vb3 0.01692f
C196 a_930_n486# a_1910_n400# 0
C197 a_n1814_n400# Vb5 0.00775f
C198 a_n246_n400# Vb3 0.01859f
C199 a_n834_n400# a_n246_n486# 0
C200 Vb4 a_n834_400# 0.07821f
C201 Vb3 a_n1226_400# 0
C202 Vb7 a_n1814_n486# 0
C203 a_1126_n400# a_930_n486# 0.05016f
C204 a_n246_n486# a_n834_400# 0.00197f
C205 a_n1814_n400# a_n2010_400# 0.05016f
C206 a_930_n486# a_342_400# 0.00197f
C207 a_n1422_n486# a_n638_n486# 0.01589f
C208 a_n442_n400# a_n834_400# 0.04561f
C209 a_930_n486# a_1518_n400# 0.0245f
C210 a_n1030_n400# a_n246_n486# 0
C211 a_1714_n486# Vb0 0
C212 Vb7 a_n2402_n400# 0.06729f
C213 a_538_n400# a_342_400# 0.05016f
C214 a_1910_n400# a_1518_400# 0.04561f
C215 a_n1422_n486# Vb5 0.12443f
C216 Vb1 a_146_n400# 0.0032f
C217 a_1126_n400# a_1518_400# 0.0016f
C218 a_n246_n400# Vb5 0.0032f
C219 a_1518_400# a_342_400# 0.00278f
C220 a_n1422_n486# a_n2206_n400# 0
C221 a_930_n486# a_1126_400# 0.00606f
C222 a_n1226_400# Vb5 0.04014f
C223 a_n442_n400# a_n246_n486# 0.00569f
C224 a_n2402_400# a_n2402_n400# 0.01914f
C225 a_n1422_n486# a_n2010_400# 0.00197f
C226 a_1518_400# a_1518_n400# 0.04482f
C227 a_n1422_n486# a_n2598_n400# 0
C228 a_n1422_n486# a_n1226_n400# 0.05016f
C229 Vb5 a_n2010_n400# 0.00471f
C230 a_n1226_400# a_n2010_400# 0.01589f
C231 a_n1226_400# a_n1226_n400# 0.0188f
C232 a_n1422_n486# a_n638_n400# 0.0016f
C233 a_n2206_n400# a_n2010_n400# 0.05097f
C234 a_930_n486# a_n246_n486# 0.00278f
C235 a_1126_n400# a_1322_n400# 0.05097f
C236 a_n2010_400# a_n2010_n400# 0.04482f
C237 a_1322_n400# a_342_400# 0
C238 a_1126_n400# a_930_n400# 0.05097f
C239 Vb1 a_734_n400# 0.01204f
C240 a_930_n400# a_342_400# 0.0245f
C241 Vb6 Vb5 0.01204f
C242 a_1910_n400# a_2106_n400# 0.05097f
C243 a_1518_400# a_1126_400# 0.01678f
C244 a_1322_n400# a_1518_n400# 0.05097f
C245 a_538_n400# a_n246_n486# 0.0016f
C246 Vb6 a_n2010_400# 0.07821f
C247 Vb7 a_n1422_n400# 0.0032f
C248 a_n1422_n486# Vout 0
C249 a_342_n400# a_342_400# 0.04482f
C250 a_1322_n400# a_1126_400# 0.0188f
C251 a_538_n400# a_930_n486# 0.0016f
C252 a_n1618_n400# a_n1814_n400# 0.05097f
C253 a_538_n486# a_342_400# 0.00606f
C254 a_1126_400# Vb0 0.00206f
C255 Vb5 a_n1814_n486# 0.00279f
C256 Vb1 a_2302_n400# 0.00263f
C257 Vout a_n2010_n400# 0.0301f
C258 a_930_n486# a_1518_400# 0.00197f
C259 a_n50_400# Vb2 0.00206f
C260 a_2106_n486# a_2302_n400# 0.01914f
C261 a_342_n400# a_n834_400# 0
C262 a_n2010_400# a_n1814_n486# 0.00606f
C263 a_930_n400# a_n246_n486# 0
C264 Vb1 a_n50_400# 0
C265 Vb5 a_n2402_n400# 0
C266 a_1126_n400# Vb3 0
C267 Vb3 a_n50_n400# 0.0496f
C268 Vb3 a_342_400# 0.00625f
C269 a_n2206_n400# a_n2402_n400# 0.05097f
C270 a_n1422_n486# a_n1618_n400# 0.00569f
C271 a_n2010_400# a_n2402_n400# 0.0016f
C272 a_1322_n400# a_930_n486# 0.04561f
C273 a_n2598_n400# a_n2402_n400# 0.05097f
C274 a_n834_n400# Vb3 0.00471f
C275 a_930_n486# a_930_n400# 0.04482f
C276 a_2106_n486# B 0.59545f
C277 a_1714_n486# B 0.53953f
C278 Vb0 B 0.36617f
C279 a_1518_400# B 0.9199f
C280 Vb1 B 0.50091f
C281 a_1126_400# B 0.53659f
C282 a_930_n486# B 0.89529f
C283 a_538_n486# B 0.53579f
C284 Vb2 B 0.34078f
C285 a_342_400# B 0.89137f
C286 Vb3 B 0.46013f
C287 a_n50_400# B 0.53579f
C288 a_n246_n486# B 0.89111f
C289 a_n638_n486# B 0.53579f
C290 Vb4 B 0.34078f
C291 a_n834_400# B 0.89111f
C292 Vb5 B 0.46087f
C293 a_n1226_400# B 0.53638f
C294 a_n1422_n486# B 0.89446f
C295 a_n1814_n486# B 0.53795f
C296 Vb6 B 0.34245f
C297 a_n2010_400# B 0.89767f
C298 Vout B 0.70446f
C299 Vb7 B 0.71021f
C300 a_n2402_400# B 0.5834f
C301 B.t14 B 0.83386f
C302 B.t1 B 0.63443f
.ends

.subckt st_2v1 A VSS Y a_142_n594# VDD a_142_n38#
X0 a_142_n38# Y VSS.t0 VDD sg13_lv_pmos ad=0.204p pd=1.88u as=0.204p ps=1.88u w=0.6u l=0.13u
X1 Y A a_142_n38# VDD sg13_lv_pmos ad=0.408p pd=3.08u as=0.228p ps=1.58u w=1.2u l=0.13u
X2 VDD Y a_142_n594# VSS.t1 sg13_lv_nmos ad=0.204p pd=1.88u as=0.204p ps=1.88u w=0.6u l=0.13u
X3 a_142_n594# A VSS.t3 VSS.t2 sg13_lv_nmos ad=0.228p pd=1.58u as=0.408p ps=3.08u w=1.2u l=0.13u
X4 a_142_n38# A VDD VDD sg13_lv_pmos ad=0.228p pd=1.58u as=0.408p ps=3.08u w=1.2u l=0.13u
X5 Y A a_142_n594# VSS.t4 sg13_lv_nmos ad=0.408p pd=3.08u as=0.228p ps=1.58u w=1.2u l=0.13u
R0 VSS.n2 VSS.t2 567.396
R1 VSS.t2 VSS.t1 181.035
R2 VSS.t1 VSS.t4 7.91862
R3 VSS.n0 VSS.t3 5.66717
R4 VSS.n1 VSS.n2 0.27313
R5 VSS.n1 VSS.n0 0.979865
R6 VSS.n1 VSS.t0 1.37141
R7 VSS.n2 VSS.t4 1.59233
R8 VSS VSS.n0 1.05085
R9 VSS VSS.t0 1.01184
C0 A VDD 0.62845f
C1 Y a_142_n38# 0.13526f
C2 Y VDD 0.33674f
C3 A a_142_n594# 0.07796f
C4 a_142_n38# VDD 0.10773f
C5 a_142_n594# Y 0.13526f
C6 a_142_n594# VDD 0.04673f
C7 A Y 0.08875f
C8 A a_142_n38# 0.07796f
C9 a_142_n594# VSS 0.34882f
C10 a_142_n38# VSS 0.83674f
C11 VDD VSS 0.84883f
C12 VSS.t0 VSS 0.3061f
.ends

.subckt st_8v1 A VSS Y a_142_n594# VDD a_142_n38#
X0 a_142_n38# Y VSS VDD sg13_lv_pmos ad=0.204p pd=1.88u as=0.204p ps=1.88u w=0.6u l=0.13u
X1 Y A a_142_n38# VDD sg13_lv_pmos ad=1.632p pd=10.28u as=0.912p ps=5.18u w=4.8u l=0.13u
X2 VDD Y a_142_n594# VSS.t0 sg13_lv_nmos ad=0.204p pd=1.88u as=0.204p ps=1.88u w=0.6u l=0.13u
X3 a_142_n594# A VSS.t2 VSS.t1 sg13_lv_nmos ad=0.912p pd=5.18u as=1.632p ps=10.28u w=4.8u l=0.13u
X4 a_142_n38# A VDD VDD sg13_lv_pmos ad=0.912p pd=5.18u as=1.632p ps=10.28u w=4.8u l=0.13u
X5 Y A a_142_n594# VSS.t3 sg13_lv_nmos ad=1.632p pd=10.28u as=0.912p ps=5.18u w=4.8u l=0.13u
R0 VSS.n0 VSS.t1 300.553
R1 VSS.t1 VSS.t0 95.9535
R2 VSS.t0 VSS.t3 4.44483
R3 VSS.n0 VSS.t3 1.58814
R4 VSS VSS.n0 1.34415
R5 VSS.n0 VSS.t2 1.21479
C0 Y VDD 0.57409f
C1 VDD A 0.89256f
C2 a_142_n594# VDD 0.05209f
C3 a_142_n38# Y 0.40731f
C4 a_142_n38# A 0.1467f
C5 Y A 0.1567f
C6 a_142_n594# Y 0.40731f
C7 a_142_n594# A 0.1467f
C8 a_142_n38# VDD 0.37982f
C9 a_142_n594# VSS 0.77976f
C10 a_142_n38# VSS 1.26589f
C11 VDD VSS 1.20559f
.ends

.subckt tt_um_nikleberg_mixer VDPWR VGND uio_oe[0] uio_oe[1] uio_oe[2] uio_in[0]
+ uio_in[1] uio_oe[3] uio_oe[4] ui_in[2] uio_oe[5] uio_in[3] uio_out[5] uio_out[3]
+ uio_in[6] uio_out[7] uio_in[4] uio_oe[6] uio_oe[7] uio_in[5] uio_in[7] uo_out[4]
+ uo_out[5] uo_out[6] ui_in[0] uo_out[7]  ui_in[1] uio_in[2] ui_in[3] ui_in[4]
+ ui_in[5] ui_in[6] ui_in[7] uo_out[3] uo_out[2] uo_out[1] uo_out[0] uio_out[0]
+ uio_out[1] uio_out[2] uio_out[4] uio_out[6]
Xst_1v1_0 uio_in[2] uio_oe[2] uio_out[3] st_1v1_0/a_142_n594# VDPWR st_1v1_0/a_142_n38#
+ st_1v1
Xst_1v1_1 st_8v1_0/A uio_oe[2] uo_out[0] st_1v1_1/a_142_n594# VDPWR st_1v1_1/a_142_n38#
+ st_1v1
Xst_4v1_0 uio_in[6] uio_oe[2] uio_out[7] st_4v1_0/a_142_n594# VDPWR st_4v1_0/a_142_n38#
+ st_4v1
Xst_4v1_1 st_8v1_0/A uio_oe[2] uo_out[2] st_4v1_1/a_142_n594# VDPWR st_4v1_1/a_142_n38#
+ st_4v1
Xr2r_0 uio_oe[2] r2r_0/a_2302_n400# r2r_0/a_1910_n400# ui_in[6] ui_in[5] r2r_0/a_n1814_n486#
+ r2r_0/a_1518_400# r2r_0/a_930_n400# r2r_0/a_146_n400# ui_in[4] ui_in[3] ui_in[1]
+ ui_in[2] r2r_0/a_n246_n400# r2r_0/a_2106_n486# r2r_0/a_1714_n486# ui_in[0] r2r_0/a_n1618_n400#
+ r2r_0/a_1126_400# st_8v1_0/A r2r_0/a_1518_n400# r2r_0/a_n50_n400# r2r_0/a_n1422_n400#
+ r2r_0/a_538_n400# r2r_0/a_1322_n400# r2r_0/a_n50_400# r2r_0/a_342_n400# r2r_0/a_n638_n400#
+ r2r_0/a_n2402_400# r2r_0/a_342_400# r2r_0/a_n442_n400# r2r_0/a_n1814_n400# r2r_0/a_n2206_n400#
+ r2r_0/a_n2010_400# r2r_0/a_930_n486# r2r_0/a_2106_n400# r2r_0/a_1714_n400# r2r_0/a_n2010_n400#
+ r2r_0/a_n246_n486# r2r_0/a_734_n400# r2r_0/a_n1422_n486# r2r_0/a_n2598_n400# r2r_0/a_n834_n400#
+ r2r_0/a_538_n486# r2r_0/a_n1226_400# r2r_0/a_2498_n400# r2r_0/a_n1226_n400# r2r_0/a_n2402_n400#
+ r2r_0/a_n638_n486# r2r_0/a_1126_n400# r2r_0/a_n834_400# r2r_0/a_n1030_n400# ui_in[7]
+ r2r
Xst_2v1_0 uio_in[4] uio_oe[2] uio_out[5] st_2v1_0/a_142_n594# VDPWR st_2v1_0/a_142_n38#
+ st_2v1
Xst_2v1_1 st_8v1_0/A uio_oe[2] uo_out[1] st_2v1_1/a_142_n594# VDPWR st_2v1_1/a_142_n38#
+ st_2v1
Xst_8v1_0 st_8v1_0/A uio_oe[2] uo_out[3] st_8v1_0/a_142_n594# VDPWR st_8v1_0/a_142_n38#
+ st_8v1
R0 uio_oe[7].n4 uio_oe[7].n3 12.9334
R1 uio_oe[7].n5 uio_oe[7].n4 12.9137
R2 VDPWR uio_oe[7].n1 9.52067
R3 VDPWR uio_oe[7].n11 9.3505
R4 uio_oe[7].n10 VDPWR 9.3505
R5 uio_oe[7].n7 VDPWR 9.3505
R6 uio_oe[7].n4 uio_oe[7].n2 9.16722
R7 uio_oe[7].n6 uio_oe[7].n1 8.2505
R8 uio_oe[7].n11 uio_oe[7].n0 8.2505
R9 uio_oe[7].n10 uio_oe[7].n9 8.2505
R10 uio_oe[7].n8 uio_oe[7].n7 8.2505
R11 uio_oe[7].n3 uio_oe[7].n0 5.374
R12 uio_oe[7].n9 uio_oe[7].n2 5.374
R13 uio_oe[7].n8 uio_oe[7].n5 5.374
R14 VDPWR uio_oe[7] 5.06017
R15 uio_oe[7].n3 VDPWR 3.977
R16 uio_oe[7].n5 VDPWR 3.977
R17 VDPWR uio_oe[7].n2 3.977
R18 uio_oe[3] uio_oe[7].n6 2.349
R19 uio_oe[7].n6 VDPWR 1.27068
R20 VDPWR uio_oe[7].n1 1.27068
R21 VDPWR uio_oe[7].n0 1.1005
R22 uio_oe[7].n11 VDPWR 1.1005
R23 uio_oe[7].n7 VDPWR 1.1005
R24 VDPWR uio_oe[7].n8 1.1005
R25 uio_oe[7].n9 VDPWR 1.1005
R26 VDPWR uio_oe[7].n10 1.1005
R27 uio_oe[7] uio_oe[5] 1.0565
R28 uio_oe[5] uio_oe[3] 1.0565
R29 uio_oe[5].n4 uio_oe[5].n3 12.9334
R30 uio_oe[5].n5 uio_oe[5].n4 12.9137
R31 VDPWR uio_oe[5].n1 9.52067
R32 VDPWR uio_oe[5].n11 9.3505
R33 uio_oe[5].n10 VDPWR 9.3505
R34 uio_oe[5].n7 VDPWR 9.3505
R35 uio_oe[5].n4 uio_oe[5].n2 9.16722
R36 uio_oe[5].n6 uio_oe[5].n1 8.2505
R37 uio_oe[5].n11 uio_oe[5].n0 8.2505
R38 uio_oe[5].n10 uio_oe[5].n9 8.2505
R39 uio_oe[5].n8 uio_oe[5].n7 8.2505
R40 uio_oe[5].n3 uio_oe[5].n0 5.374
R41 uio_oe[5].n9 uio_oe[5].n2 5.374
R42 uio_oe[5].n8 uio_oe[5].n5 5.374
R43 VDPWR uio_oe[7] 5.06017
R44 uio_oe[5].n3 VDPWR 3.977
R45 uio_oe[5].n5 VDPWR 3.977
R46 VDPWR uio_oe[5].n2 3.977
R47 uio_oe[3] uio_oe[5].n6 2.349
R48 uio_oe[5].n6 VDPWR 1.27068
R49 VDPWR uio_oe[5].n1 1.27068
R50 VDPWR uio_oe[5].n0 1.1005
R51 uio_oe[5].n11 VDPWR 1.1005
R52 uio_oe[5].n7 VDPWR 1.1005
R53 VDPWR uio_oe[5].n8 1.1005
R54 uio_oe[5].n9 VDPWR 1.1005
R55 VDPWR uio_oe[5].n10 1.1005
R56 uio_oe[7] uio_oe[5] 1.0565
R57 uio_oe[5] uio_oe[3] 1.0565
R58 uio_oe[3].n4 uio_oe[3].n3 12.9334
R59 uio_oe[3].n5 uio_oe[3].n4 12.9137
R60 VDPWR uio_oe[3].n1 9.52067
R61 VDPWR uio_oe[3].n11 9.3505
R62 uio_oe[3].n10 VDPWR 9.3505
R63 uio_oe[3].n7 VDPWR 9.3505
R64 uio_oe[3].n4 uio_oe[3].n2 9.16722
R65 uio_oe[3].n6 uio_oe[3].n1 8.2505
R66 uio_oe[3].n11 uio_oe[3].n0 8.2505
R67 uio_oe[3].n10 uio_oe[3].n9 8.2505
R68 uio_oe[3].n8 uio_oe[3].n7 8.2505
R69 uio_oe[3].n3 uio_oe[3].n0 5.374
R70 uio_oe[3].n9 uio_oe[3].n2 5.374
R71 uio_oe[3].n8 uio_oe[3].n5 5.374
R72 VDPWR uio_oe[7] 5.06017
R73 uio_oe[3].n3 VDPWR 3.977
R74 uio_oe[3].n5 VDPWR 3.977
R75 VDPWR uio_oe[3].n2 3.977
R76 uio_oe[3] uio_oe[3].n6 2.349
R77 uio_oe[3].n6 VDPWR 1.27068
R78 VDPWR uio_oe[3].n1 1.27068
R79 VDPWR uio_oe[3].n0 1.1005
R80 uio_oe[3].n11 VDPWR 1.1005
R81 uio_oe[3].n7 VDPWR 1.1005
R82 VDPWR uio_oe[3].n8 1.1005
R83 uio_oe[3].n9 VDPWR 1.1005
R84 VDPWR uio_oe[3].n10 1.1005
R85 uio_oe[7] uio_oe[5] 1.0565
R86 uio_oe[5] uio_oe[3] 1.0565
R87 uio_oe[2].n23 uio_oe[2].n20 211874
R88 uio_oe[2].n29 uio_oe[2].n20 103825
R89 uio_oe[2].n25 uio_oe[2].n20 19200
R90 uio_oe[2].n26 uio_oe[2].n25 10423
R91 uio_oe[2].n37 uio_oe[2].n20 9600
R92 uio_oe[2].n25 uio_oe[2].n24 8527.34
R93 uio_oe[2].n38 uio_oe[2].n37 6963.32
R94 uio_oe[2].n30 uio_oe[2].n29 6925
R95 uio_oe[2].n30 uio_oe[2].n26 4256.55
R96 uio_oe[2].n31 uio_oe[2].n30 2531.79
R97 uio_oe[2].n38 uio_oe[2].n2 1492.58
R98 uio_oe[2].n31 uio_oe[2].n22 1238.26
R99 uio_oe[2].n37 uio_oe[2].n0 921.256
R100 uio_oe[2].n24 uio_oe[2].n23 772.597
R101 uio_oe[2].n23 uio_oe[2].n2 771.902
R102 uio_oe[2].n26 uio_oe[2].n22 508.514
R103 uio_oe[2].n28 uio_oe[2].n22 376.337
R104 uio_oe[2].n0 uio_oe[2].n7 19.3045
R105 uio_oe[2].n39 uio_oe[2].n38 47.9629
R106 uio_oe[2].n1 uio_oe[2].n0 1.18929
R107 uio_oe[2].n36 uio_oe[2].n12 13.4605
R108 uio_oe[2].n35 uio_oe[2].n34 13.4605
R109 uio_oe[2].n28 uio_oe[2].n11 11.7431
R110 uio_oe[2].n40 uio_oe[2].n19 9.89219
R111 uio_oe[2].n11 uio_oe[2].n10 9.412
R112 uio_oe[2].n16 uio_oe[2].n46 9.3505
R113 uio_oe[2].n45 uio_oe[2].n16 9.3505
R114 uio_oe[2].n42 uio_oe[2].n16 9.3505
R115 uio_oe[2].n40 uio_oe[2].n39 9.28788
R116 uio_oe[2].n27 uio_oe[2].n21 9.16722
R117 uio_oe[2].n33 uio_oe[2].n18 9.16722
R118 uio_oe[2].n32 uio_oe[2].n17 9.16722
R119 uio_oe[2].n34 uio_oe[2].n12 9.08597
R120 uio_oe[2].n4 uio_oe[2].n31 8.74947
R121 uio_oe[2].n41 uio_oe[2].n10 8.2505
R122 uio_oe[2].n46 uio_oe[2].n14 8.2505
R123 uio_oe[2].n45 uio_oe[2].n44 8.2505
R124 uio_oe[2].n43 uio_oe[2].n42 8.2505
R125 uio_oe[2].n35 uio_oe[2].n13 7.91794
R126 uio_oe[2].n11 uio_oe[2].n27 5.0385
R127 uio_oe[2].n11 uio_oe[2].n18 5.0385
R128 uio_oe[2].n11 uio_oe[2].n17 5.0385
R129 uio_oe[2].n16 uio_oe[6] 4.90067
R130 uio_oe[2].n1 uio_oe[2].n36 4.37499
R131 uio_oe[2].n27 uio_oe[2].n14 4.3125
R132 uio_oe[2].n44 uio_oe[2].n18 4.3125
R133 uio_oe[2].n43 uio_oe[2].n17 4.3125
R134 uio_oe[2].n13 uio_oe[2].n12 4.2505
R135 uio_oe[2].n36 uio_oe[2].n5 4.2505
R136 uio_oe[2].n5 uio_oe[2].n4 4.2505
R137 uio_oe[2].n7 uio_oe[2].n4 4.2505
R138 uio_oe[2].n1 uio_oe[2].n4 4.2505
R139 uio_oe[2].n2 uio_oe[2].n3 0.608453
R140 uio_oe[2].n13 uio_oe[2].n4 3.56248
R141 uio_oe[2].n13 uio_oe[2].n32 3.30951
R142 uio_oe[2].n24 uio_oe[2].n19 2.82702
R143 uio_oe[2].n1 uio_oe[2].n21 2.7276
R144 uio_oe[2] uio_oe[2].n41 2.5085
R145 uio_oe[2].n39 uio_oe[2].n3 2.52463
R146 uio_oe[2].n7 uio_oe[2].n8 0.62937
R147 uio_oe[2].n6 uio_oe[2].n5 0.575428
R148 uio_oe[2].n15 uio_oe[2].n10 1.27068
R149 uio_oe[2].n41 uio_oe[2].n9 1.14951
R150 uio_oe[2].n15 uio_oe[2].n14 1.1005
R151 uio_oe[2].n46 uio_oe[2].n9 1.1005
R152 uio_oe[2].n9 uio_oe[2].n40 1.1005
R153 uio_oe[2].n42 uio_oe[2].n9 1.1005
R154 uio_oe[2].n9 uio_oe[2].n45 1.1005
R155 uio_oe[2].n44 uio_oe[2].n15 1.1005
R156 uio_oe[2].n15 uio_oe[2].n43 1.1005
R157 uio_oe[2].n8 uio_oe[2].n33 1.50834
R158 uio_oe[2].n32 uio_oe[2].n6 1.52551
R159 uio_oe[2].n29 uio_oe[2].n28 1.063
R160 uio_oe[6] uio_oe[4] 1.0565
R161 uio_oe[4] uio_oe[2] 1.0565
R162 uio_oe[2].n9 VGND 1.04885
R163 uio_oe[2].n11 VGND 1.03636
R164 uio_oe[2].n34 uio_oe[2].n7 1.0362
R165 VGND uio_oe[2].n16 0.927688
R166 uio_oe[2].n15 VGND 0.927688
R167 uio_oe[2].n3 uio_oe[2].n19 1.98681
R168 uio_oe[2].n33 uio_oe[2].n6 2.22157
R169 uio_oe[2].n21 uio_oe[2].n8 2.25753
R170 uio_oe[2].n5 uio_oe[2].n35 1.50134
R171 VGND.n24 VGND.n21 211874
R172 VGND.n30 VGND.n21 103825
R173 VGND.n26 VGND.n21 19200
R174 VGND.n27 VGND.n26 10423
R175 VGND.n38 VGND.n21 9600
R176 VGND.n26 VGND.n25 8527.34
R177 VGND.n39 VGND.n38 6963.32
R178 VGND.n31 VGND.n30 6925
R179 VGND.n31 VGND.n27 4256.55
R180 VGND.n32 VGND.n31 2531.79
R181 VGND.n39 VGND.n2 1492.58
R182 VGND.n32 VGND.n23 1238.26
R183 VGND.n38 VGND.n0 921.256
R184 VGND.n25 VGND.n24 772.597
R185 VGND.n24 VGND.n2 771.902
R186 VGND.n27 VGND.n23 508.514
R187 VGND.n29 VGND.n23 376.337
R188 VGND.n0 VGND.n7 19.3045
R189 VGND.n40 VGND.n39 47.9629
R190 VGND.n1 VGND.n0 1.18929
R191 VGND.n37 VGND.n12 13.4605
R192 VGND.n36 VGND.n35 13.4605
R193 VGND.n29 VGND.n11 11.7431
R194 VGND.n41 VGND.n20 9.89219
R195 VGND.n11 VGND.n10 9.412
R196 VGND.n46 VGND.n16 9.3505
R197 VGND.n16 VGND.n45 9.3505
R198 VGND.n42 VGND.n16 9.3505
R199 VGND.n41 VGND.n40 9.28788
R200 VGND.n28 VGND.n22 9.16722
R201 VGND.n34 VGND.n18 9.16722
R202 VGND.n33 VGND.n17 9.16722
R203 VGND.n35 VGND.n12 9.08597
R204 VGND.n4 VGND.n32 8.74947
R205 VGND.n46 VGND.n14 8.2505
R206 VGND.n45 VGND.n44 8.2505
R207 VGND.n43 VGND.n42 8.2505
R208 VGND.n19 VGND.n10 8.2505
R209 VGND.n36 VGND.n13 7.91794
R210 VGND.n11 VGND.n28 5.0385
R211 VGND.n11 VGND.n18 5.0385
R212 VGND.n11 VGND.n17 5.0385
R213 uio_oe[6] VGND.n16 4.90067
R214 VGND.n1 VGND.n37 4.37499
R215 VGND.n28 VGND.n14 4.3125
R216 VGND.n44 VGND.n18 4.3125
R217 VGND.n43 VGND.n17 4.3125
R218 VGND.n13 VGND.n12 4.2505
R219 VGND.n37 VGND.n5 4.2505
R220 VGND.n5 VGND.n4 4.2505
R221 VGND.n7 VGND.n4 4.2505
R222 VGND.n1 VGND.n4 4.2505
R223 VGND.n2 VGND.n3 0.608453
R224 VGND.n13 VGND.n4 3.56248
R225 VGND.n13 VGND.n33 3.30951
R226 VGND.n25 VGND.n20 2.82702
R227 VGND.n1 VGND.n22 2.7276
R228 VGND.n19 uio_oe[2] 2.5085
R229 VGND.n40 VGND.n3 2.52463
R230 VGND.n7 VGND.n8 0.62937
R231 VGND.n6 VGND.n5 0.575428
R232 VGND.n15 VGND.n10 1.27068
R233 VGND.n9 VGND.n19 1.14951
R234 VGND.n15 VGND.n14 1.1005
R235 VGND.n9 VGND.n46 1.1005
R236 VGND.n9 VGND.n41 1.1005
R237 VGND.n42 VGND.n9 1.1005
R238 VGND.n45 VGND.n9 1.1005
R239 VGND.n44 VGND.n15 1.1005
R240 VGND.n15 VGND.n43 1.1005
R241 VGND.n8 VGND.n34 1.50834
R242 VGND.n33 VGND.n6 1.52551
R243 VGND.n30 VGND.n29 1.063
R244 uio_oe[4] uio_oe[6] 1.0565
R245 uio_oe[2] uio_oe[4] 1.0565
R246 VGND VGND.n9 1.04885
R247 VGND.n11 VGND 1.03636
R248 VGND.n35 VGND.n7 1.0362
R249 VGND.n16 VGND 0.927688
R250 VGND.n15 VGND 0.927688
R251 VGND.n3 VGND.n20 1.98681
R252 VGND.n34 VGND.n6 2.22157
R253 VGND.n22 VGND.n8 2.25753
R254 VGND.n5 VGND.n36 1.50134
R255 uio_oe[6].n23 uio_oe[6].n20 211874
R256 uio_oe[6].n29 uio_oe[6].n20 103825
R257 uio_oe[6].n25 uio_oe[6].n20 19200
R258 uio_oe[6].n26 uio_oe[6].n25 10423
R259 uio_oe[6].n37 uio_oe[6].n20 9600
R260 uio_oe[6].n25 uio_oe[6].n24 8527.34
R261 uio_oe[6].n38 uio_oe[6].n37 6963.32
R262 uio_oe[6].n30 uio_oe[6].n29 6925
R263 uio_oe[6].n30 uio_oe[6].n26 4256.55
R264 uio_oe[6].n31 uio_oe[6].n30 2531.79
R265 uio_oe[6].n38 uio_oe[6].n2 1492.58
R266 uio_oe[6].n31 uio_oe[6].n22 1238.26
R267 uio_oe[6].n37 uio_oe[6].n0 921.256
R268 uio_oe[6].n24 uio_oe[6].n23 772.597
R269 uio_oe[6].n23 uio_oe[6].n2 771.902
R270 uio_oe[6].n26 uio_oe[6].n22 508.514
R271 uio_oe[6].n28 uio_oe[6].n22 376.337
R272 uio_oe[6].n0 uio_oe[6].n7 19.3045
R273 uio_oe[6].n39 uio_oe[6].n38 47.9629
R274 uio_oe[6].n1 uio_oe[6].n0 1.18929
R275 uio_oe[6].n36 uio_oe[6].n12 13.4605
R276 uio_oe[6].n35 uio_oe[6].n34 13.4605
R277 uio_oe[6].n28 uio_oe[6].n11 11.7431
R278 uio_oe[6].n40 uio_oe[6].n19 9.89219
R279 uio_oe[6].n11 uio_oe[6].n10 9.412
R280 uio_oe[6].n16 uio_oe[6].n46 9.3505
R281 uio_oe[6].n45 uio_oe[6].n16 9.3505
R282 uio_oe[6].n42 uio_oe[6].n16 9.3505
R283 uio_oe[6].n40 uio_oe[6].n39 9.28788
R284 uio_oe[6].n27 uio_oe[6].n21 9.16722
R285 uio_oe[6].n33 uio_oe[6].n18 9.16722
R286 uio_oe[6].n32 uio_oe[6].n17 9.16722
R287 uio_oe[6].n34 uio_oe[6].n12 9.08597
R288 uio_oe[6].n4 uio_oe[6].n31 8.74947
R289 uio_oe[6].n41 uio_oe[6].n10 8.2505
R290 uio_oe[6].n46 uio_oe[6].n14 8.2505
R291 uio_oe[6].n45 uio_oe[6].n44 8.2505
R292 uio_oe[6].n43 uio_oe[6].n42 8.2505
R293 uio_oe[6].n35 uio_oe[6].n13 7.91794
R294 uio_oe[6].n11 uio_oe[6].n27 5.0385
R295 uio_oe[6].n11 uio_oe[6].n18 5.0385
R296 uio_oe[6].n11 uio_oe[6].n17 5.0385
R297 uio_oe[6].n16 uio_oe[6] 4.90067
R298 uio_oe[6].n1 uio_oe[6].n36 4.37499
R299 uio_oe[6].n27 uio_oe[6].n14 4.3125
R300 uio_oe[6].n44 uio_oe[6].n18 4.3125
R301 uio_oe[6].n43 uio_oe[6].n17 4.3125
R302 uio_oe[6].n13 uio_oe[6].n12 4.2505
R303 uio_oe[6].n36 uio_oe[6].n5 4.2505
R304 uio_oe[6].n5 uio_oe[6].n4 4.2505
R305 uio_oe[6].n7 uio_oe[6].n4 4.2505
R306 uio_oe[6].n1 uio_oe[6].n4 4.2505
R307 uio_oe[6].n2 uio_oe[6].n3 0.608453
R308 uio_oe[6].n13 uio_oe[6].n4 3.56248
R309 uio_oe[6].n13 uio_oe[6].n32 3.30951
R310 uio_oe[6].n24 uio_oe[6].n19 2.82702
R311 uio_oe[6].n1 uio_oe[6].n21 2.7276
R312 uio_oe[2] uio_oe[6].n41 2.5085
R313 uio_oe[6].n39 uio_oe[6].n3 2.52463
R314 uio_oe[6].n7 uio_oe[6].n8 0.62937
R315 uio_oe[6].n6 uio_oe[6].n5 0.575428
R316 uio_oe[6].n15 uio_oe[6].n10 1.27068
R317 uio_oe[6].n41 uio_oe[6].n9 1.14951
R318 uio_oe[6].n15 uio_oe[6].n14 1.1005
R319 uio_oe[6].n46 uio_oe[6].n9 1.1005
R320 uio_oe[6].n9 uio_oe[6].n40 1.1005
R321 uio_oe[6].n42 uio_oe[6].n9 1.1005
R322 uio_oe[6].n9 uio_oe[6].n45 1.1005
R323 uio_oe[6].n44 uio_oe[6].n15 1.1005
R324 uio_oe[6].n15 uio_oe[6].n43 1.1005
R325 uio_oe[6].n8 uio_oe[6].n33 1.50834
R326 uio_oe[6].n32 uio_oe[6].n6 1.52551
R327 uio_oe[6].n29 uio_oe[6].n28 1.063
R328 uio_oe[6] uio_oe[4] 1.0565
R329 uio_oe[4] uio_oe[2] 1.0565
R330 uio_oe[6].n9 VGND 1.04885
R331 uio_oe[6].n11 VGND 1.03636
R332 uio_oe[6].n34 uio_oe[6].n7 1.0362
R333 VGND uio_oe[6].n16 0.927688
R334 uio_oe[6].n15 VGND 0.927688
R335 uio_oe[6].n3 uio_oe[6].n19 1.98681
R336 uio_oe[6].n33 uio_oe[6].n6 2.22157
R337 uio_oe[6].n21 uio_oe[6].n8 2.25753
R338 uio_oe[6].n5 uio_oe[6].n35 1.50134
R339 uio_oe[4].n23 uio_oe[4].n20 211874
R340 uio_oe[4].n29 uio_oe[4].n20 103825
R341 uio_oe[4].n25 uio_oe[4].n20 19200
R342 uio_oe[4].n26 uio_oe[4].n25 10423
R343 uio_oe[4].n37 uio_oe[4].n20 9600
R344 uio_oe[4].n25 uio_oe[4].n24 8527.34
R345 uio_oe[4].n38 uio_oe[4].n37 6963.32
R346 uio_oe[4].n30 uio_oe[4].n29 6925
R347 uio_oe[4].n30 uio_oe[4].n26 4256.55
R348 uio_oe[4].n31 uio_oe[4].n30 2531.79
R349 uio_oe[4].n38 uio_oe[4].n2 1492.58
R350 uio_oe[4].n31 uio_oe[4].n22 1238.26
R351 uio_oe[4].n37 uio_oe[4].n0 921.256
R352 uio_oe[4].n24 uio_oe[4].n23 772.597
R353 uio_oe[4].n23 uio_oe[4].n2 771.902
R354 uio_oe[4].n26 uio_oe[4].n22 508.514
R355 uio_oe[4].n28 uio_oe[4].n22 376.337
R356 uio_oe[4].n0 uio_oe[4].n7 19.3045
R357 uio_oe[4].n39 uio_oe[4].n38 47.9629
R358 uio_oe[4].n1 uio_oe[4].n0 1.18929
R359 uio_oe[4].n36 uio_oe[4].n12 13.4605
R360 uio_oe[4].n35 uio_oe[4].n34 13.4605
R361 uio_oe[4].n28 uio_oe[4].n11 11.7431
R362 uio_oe[4].n40 uio_oe[4].n19 9.89219
R363 uio_oe[4].n11 uio_oe[4].n10 9.412
R364 uio_oe[4].n16 uio_oe[4].n46 9.3505
R365 uio_oe[4].n45 uio_oe[4].n16 9.3505
R366 uio_oe[4].n42 uio_oe[4].n16 9.3505
R367 uio_oe[4].n40 uio_oe[4].n39 9.28788
R368 uio_oe[4].n27 uio_oe[4].n21 9.16722
R369 uio_oe[4].n33 uio_oe[4].n18 9.16722
R370 uio_oe[4].n32 uio_oe[4].n17 9.16722
R371 uio_oe[4].n34 uio_oe[4].n12 9.08597
R372 uio_oe[4].n4 uio_oe[4].n31 8.74947
R373 uio_oe[4].n41 uio_oe[4].n10 8.2505
R374 uio_oe[4].n46 uio_oe[4].n14 8.2505
R375 uio_oe[4].n45 uio_oe[4].n44 8.2505
R376 uio_oe[4].n43 uio_oe[4].n42 8.2505
R377 uio_oe[4].n35 uio_oe[4].n13 7.91794
R378 uio_oe[4].n11 uio_oe[4].n27 5.0385
R379 uio_oe[4].n11 uio_oe[4].n18 5.0385
R380 uio_oe[4].n11 uio_oe[4].n17 5.0385
R381 uio_oe[4].n16 uio_oe[6] 4.90067
R382 uio_oe[4].n1 uio_oe[4].n36 4.37499
R383 uio_oe[4].n27 uio_oe[4].n14 4.3125
R384 uio_oe[4].n44 uio_oe[4].n18 4.3125
R385 uio_oe[4].n43 uio_oe[4].n17 4.3125
R386 uio_oe[4].n13 uio_oe[4].n12 4.2505
R387 uio_oe[4].n36 uio_oe[4].n5 4.2505
R388 uio_oe[4].n5 uio_oe[4].n4 4.2505
R389 uio_oe[4].n7 uio_oe[4].n4 4.2505
R390 uio_oe[4].n1 uio_oe[4].n4 4.2505
R391 uio_oe[4].n2 uio_oe[4].n3 0.608453
R392 uio_oe[4].n13 uio_oe[4].n4 3.56248
R393 uio_oe[4].n13 uio_oe[4].n32 3.30951
R394 uio_oe[4].n24 uio_oe[4].n19 2.82702
R395 uio_oe[4].n1 uio_oe[4].n21 2.7276
R396 uio_oe[2] uio_oe[4].n41 2.5085
R397 uio_oe[4].n39 uio_oe[4].n3 2.52463
R398 uio_oe[4].n7 uio_oe[4].n8 0.62937
R399 uio_oe[4].n6 uio_oe[4].n5 0.575428
R400 uio_oe[4].n15 uio_oe[4].n10 1.27068
R401 uio_oe[4].n41 uio_oe[4].n9 1.14951
R402 uio_oe[4].n15 uio_oe[4].n14 1.1005
R403 uio_oe[4].n46 uio_oe[4].n9 1.1005
R404 uio_oe[4].n9 uio_oe[4].n40 1.1005
R405 uio_oe[4].n42 uio_oe[4].n9 1.1005
R406 uio_oe[4].n9 uio_oe[4].n45 1.1005
R407 uio_oe[4].n44 uio_oe[4].n15 1.1005
R408 uio_oe[4].n15 uio_oe[4].n43 1.1005
R409 uio_oe[4].n8 uio_oe[4].n33 1.50834
R410 uio_oe[4].n32 uio_oe[4].n6 1.52551
R411 uio_oe[4].n29 uio_oe[4].n28 1.063
R412 uio_oe[6] uio_oe[4] 1.0565
R413 uio_oe[4] uio_oe[2] 1.0565
R414 uio_oe[4].n9 VGND 1.04885
R415 uio_oe[4].n11 VGND 1.03636
R416 uio_oe[4].n34 uio_oe[4].n7 1.0362
R417 VGND uio_oe[4].n16 0.927688
R418 uio_oe[4].n15 VGND 0.927688
R419 uio_oe[4].n3 uio_oe[4].n19 1.98681
R420 uio_oe[4].n33 uio_oe[4].n6 2.22157
R421 uio_oe[4].n21 uio_oe[4].n8 2.25753
R422 uio_oe[4].n5 uio_oe[4].n35 1.50134
C0 r2r_0/a_n2010_400# ui_in[4] 0
C1 st_1v1_1/a_142_n594# uo_out[0] 0.00319f
C2 ui_in[4] ui_in[5] 0.1288f
C3 r2r_0/a_n1814_n400# ui_in[6] 0.00666f
C4 VDPWR st_4v1_0/a_142_n594# 0.01289f
C5 ui_in[3] r2r_0/a_n246_n400# 0
C6 st_2v1_1/a_142_n594# VDPWR 0.00201f
C7 st_4v1_0/a_142_n594# uio_out[7] 0.00517f
C8 st_2v1_0/a_142_n594# uio_in[4] 0.00317f
C9 st_1v1_1/a_142_n594# st_8v1_0/A 0.00325f
C10 VDPWR uio_oe[1] 0.07574f
C11 VDPWR uio_out[7] 0.27171f
C12 VDPWR r2r_0/a_930_n400# 0.00371f
C13 VDPWR uio_in[0] 0.00306f
C14 uio_in[6] uio_out[6] 0
C15 VDPWR r2r_0/a_538_n486# 0.0019f
C16 uio_in[2] uio_out[0] 0
C17 VDPWR r2r_0/a_2106_n400# 0.0135f
C18 r2r_0/a_n2206_n400# ui_in[6] 0.00339f
C19 st_1v1_0/a_142_n594# uio_out[3] 0.00216f
C20 ui_in[6] r2r_0/a_n2402_n400# 0
C21 VDPWR uio_out[1] 0.00306f
C22 uio_in[4] uio_out[0] 0
C23 uo_out[1] st_4v1_1/a_142_n38# 0
C24 r2r_0/a_n834_400# ui_in[4] 0.00188f
C25 uio_in[4] uio_out[5] 0.0653f
C26 ui_in[3] r2r_0/a_n638_n400# 0
C27 VDPWR r2r_0/a_n1422_n400# 0
C28 ui_in[4] ui_in[2] 0
C29 st_8v1_0/a_142_n594# uo_out[2] 0.00286f
C30 r2r_0/a_n638_n486# VDPWR 0
C31 uio_in[2] uio_in[7] 0
C32 uio_in[2] uio_in[5] 0
C33 uio_out[6] uio_out[5] 0.007f
C34 VDPWR r2r_0/a_2302_n400# 0.01376f
C35 VDPWR uo_out[2] 0.70218f
C36 r2r_0/a_n1814_n486# VDPWR 0.00379f
C37 uio_in[4] uio_in[7] 0
C38 VDPWR uio_in[2] 0.15685f
C39 uio_in[4] uio_in[5] 0.0073f
C40 VDPWR r2r_0/a_930_n486# 0.00719f
C41 r2r_0/a_n1618_n400# ui_in[5] 0.00182f
C42 VDPWR ui_in[6] 0.07742f
C43 VDPWR uio_in[4] 0.19887f
C44 VDPWR ui_in[4] 0.07852f
C45 uio_in[2] uio_out[1] 0
C46 r2r_0/a_n50_400# ui_in[2] 0
C47 uo_out[4] uo_out[5] 0.007f
C48 st_4v1_1/a_142_n594# VDPWR 0.00328f
C49 st_8v1_0/A uo_out[3] 0.02171f
C50 r2r_0/a_n2010_n400# st_8v1_0/A 0
C51 ui_in[2] r2r_0/a_146_n400# 0
C52 VDPWR uio_out[6] 0.00332f
C53 clk rst_n 0.007f
C54 uio_in[4] uio_out[1] 0
C55 uio_out[7] uio_out[6] 0.007f
C56 ui_in[0] r2r_0/a_1518_400# 0
C57 st_1v1_0/a_142_n38# uio_in[4] 0
C58 uo_out[1] uo_out[0] 0.28363f
C59 uio_in[6] uio_out[2] 0
C60 uio_in[6] uio_out[4] 0
C61 r2r_0/a_n50_n400# ui_in[3] 0
C62 r2r_0/a_n1226_n400# ui_in[5] 0
C63 r2r_0/a_n1422_n400# ui_in[4] 0
C64 VDPWR r2r_0/a_n2598_n400# 0
C65 uo_out[1] st_8v1_0/A 0.12182f
C66 uio_in[6] uo_out[0] 0.06252f
C67 uio_in[2] uo_out[2] 0.04892f
C68 r2r_0/a_n638_n486# ui_in[4] 0
C69 ui_in[7] ui_in[5] 0
C70 st_8v1_0/a_142_n38# VDPWR 0.00241f
C71 ui_in[0] rst_n 0.007f
C72 r2r_0/a_n2010_400# st_8v1_0/A 0
C73 VDPWR st_4v1_1/a_142_n38# 0.01032f
C74 ui_in[1] ui_in[0] 0.10932f
C75 VDPWR r2r_0/a_1322_n400# 0.00453f
C76 r2r_0/a_n1814_n486# ui_in[6] 0
C77 uo_out[7] uo_out[6] 0.007f
C78 uo_out[2] uio_in[4] 0.0434f
C79 ena VDPWR 0.00306f
C80 st_2v1_1/a_142_n38# uo_out[0] 0
C81 r2r_0/a_n1814_n400# st_8v1_0/A 0.00284f
C82 uio_in[6] uio_out[3] 0.05077f
C83 uio_in[2] uio_in[4] 1.59246f
C84 VDPWR r2r_0/a_146_n400# 0
C85 st_2v1_1/a_142_n38# st_8v1_0/A 0.00447f
C86 uio_in[6] uo_out[7] 0
C87 st_4v1_1/a_142_n594# uo_out[2] 0.00762f
C88 st_2v1_0/a_142_n594# uio_out[3] 0
C89 ui_in[6] ui_in[4] 0
C90 uio_out[5] uio_out[4] 0.007f
C91 uo_out[3] uo_out[4] 0.007f
C92 r2r_0/a_n1618_n400# VDPWR 0
C93 r2r_0/a_n2402_n400# ui_in[7] 0
C94 r2r_0/a_n2402_n400# uo_out[0] 0
C95 VDPWR r2r_0/a_n246_n400# 0
C96 r2r_0/a_n2206_n400# st_8v1_0/A 0.00534f
C97 ui_in[0] ui_in[2] 0
C98 VDPWR st_1v1_1/a_142_n38# 0.006f
C99 st_2v1_0/a_142_n38# uio_out[3] 0
C100 VDPWR uio_in[1] 0.00306f
C101 r2r_0/a_n2402_n400# st_8v1_0/A 0
C102 uio_in[1] uio_in[0] 0.007f
C103 VDPWR clk 0.00306f
C104 uo_out[5] uo_out[6] 0.007f
C105 uio_out[3] uio_out[5] 0.01592f
C106 r2r_0/a_1714_n486# VDPWR 0.00294f
C107 uo_out[7] uio_out[0] 0.007f
C108 st_8v1_0/a_142_n38# uo_out[2] 0
C109 uio_in[7] uo_out[0] 0.007f
C110 uio_in[6] uo_out[4] 0
C111 VDPWR r2r_0/a_1714_n400# 0.00575f
C112 uio_in[6] uo_out[5] 0
C113 VDPWR uio_out[2] 0.00306f
C114 r2r_0/a_n1226_n400# VDPWR 0
C115 VDPWR uio_out[4] 0.00306f
C116 VDPWR r2r_0/a_n638_n400# 0
C117 st_2v1_1/a_142_n594# uo_out[0] 0
C118 VDPWR ui_in[0] 0.18931f
C119 VDPWR uo_out[0] 0.59907f
C120 VDPWR ui_in[7] 0.07904f
C121 ui_in[6] r2r_0/a_n2402_400# 0.00133f
C122 st_2v1_1/a_142_n594# st_8v1_0/A 0.00447f
C123 ui_in[7] uio_in[0] 0.007f
C124 VDPWR st_8v1_0/A 0.79402f
C125 uio_out[1] uio_out[2] 0.007f
C126 VDPWR r2r_0/a_2498_n400# 0.00101f
C127 VDPWR uio_out[3] 0.10909f
C128 VDPWR r2r_0/a_734_n400# 0.0036f
C129 uio_in[2] uio_in[1] 0.007f
C130 ui_in[3] ui_in[5] 0
C131 VDPWR uo_out[7] 0.00306f
C132 ui_in[1] ui_in[3] 0
C133 r2r_0/a_n442_n400# ui_in[3] 0
C134 uo_out[1] uo_out[3] 0
C135 r2r_0/a_342_400# ui_in[2] 0.00132f
C136 uio_in[2] uio_out[2] 0
C137 VDPWR st_1v1_1/a_142_n594# 0.00138f
C138 uio_in[6] uo_out[3] 0.04949f
C139 r2r_0/a_n1226_400# ui_in[5] 0.00145f
C140 uo_out[2] uo_out[0] 0
C141 r2r_0/a_n834_400# ui_in[3] 0.00122f
C142 uio_in[2] uo_out[0] 0.05f
C143 uio_in[4] uio_out[2] 0
C144 ui_in[3] ui_in[2] 0.10302f
C145 r2r_0/a_n1226_n400# ui_in[4] 0
C146 uio_in[4] uio_out[4] 0
C147 VDPWR r2r_0/a_n50_n400# 0
C148 r2r_0/a_n638_n400# ui_in[4] 0.0065f
C149 r2r_0/a_n1814_n486# st_8v1_0/A 0.0013f
C150 uo_out[2] st_8v1_0/A 0.13165f
C151 VDPWR r2r_0/a_n1422_n486# 0.00209f
C152 ui_in[6] ui_in[7] 0.17457f
C153 VDPWR uo_out[4] 0.00306f
C154 uio_in[4] uo_out[0] 0.04448f
C155 VDPWR uo_out[5] 0.00306f
C156 uio_in[2] uio_out[3] 0.05458f
C157 uio_in[6] uo_out[6] 0
C158 uo_out[1] uio_in[6] 0.04841f
C159 VDPWR uio_in[3] 0.00306f
C160 ui_in[6] st_8v1_0/A 0.00154f
C161 r2r_0/a_342_400# VDPWR 0.00246f
C162 VDPWR uio_oe[0] 0.07748f
C163 uio_in[2] uo_out[7] 0
C164 uio_oe[1] uio_oe[0] 0.02784f
C165 uio_out[7] uio_oe[0] 0.02784f
C166 uio_in[4] uio_out[3] 0.09413f
C167 r2r_0/a_538_n400# ui_in[2] 0.0064f
C168 st_4v1_1/a_142_n594# st_8v1_0/A 0.00632f
C169 r2r_0/a_n2010_400# ui_in[5] 0.00213f
C170 r2r_0/a_1126_n400# VDPWR 0
C171 VDPWR r2r_0/a_n834_n400# 0
C172 uio_in[4] uo_out[7] 0
C173 VDPWR ui_in[3] 0.07965f
C174 st_2v1_0/a_142_n594# uio_in[6] 0.00231f
C175 r2r_0/a_n1814_n400# ui_in[5] 0
C176 ena clk 0.007f
C177 r2r_0/a_n2598_n400# ui_in[7] 0
C178 r2r_0/a_n2598_n400# uo_out[0] 0
C179 ui_in[1] r2r_0/a_1126_400# 0.00167f
C180 uio_in[6] st_2v1_0/a_142_n38# 0
C181 r2r_0/a_n2598_n400# st_8v1_0/A 0
C182 st_8v1_0/a_142_n594# uo_out[3] 0.01353f
C183 r2r_0/a_n1030_n400# VDPWR 0
C184 st_1v1_0/a_142_n594# uio_in[2] 0.00217f
C185 uio_in[6] uio_out[0] 0
C186 ui_in[7] r2r_0/a_n2402_400# 0.00123f
C187 uio_in[2] uo_out[4] 0
C188 VDPWR r2r_0/a_538_n400# 0.00339f
C189 uio_in[2] uo_out[5] 0
C190 st_8v1_0/A st_4v1_1/a_142_n38# 0.00632f
C191 uio_in[6] uio_out[5] 0.10538f
C192 r2r_0/a_2106_n486# VDPWR 0.0113f
C193 r2r_0/a_n2402_400# st_8v1_0/A 0
C194 st_1v1_0/a_142_n594# uio_in[4] 0.00191f
C195 uio_in[2] uio_in[3] 0.00721f
C196 VDPWR uo_out[3] 0.43388f
C197 r2r_0/a_342_n400# ui_in[2] 0
C198 r2r_0/a_n2010_n400# VDPWR 0
C199 uio_in[4] uo_out[4] 0
C200 st_2v1_0/a_142_n594# uio_out[5] 0.00317f
C201 uio_in[4] uo_out[5] 0
C202 uio_in[4] uio_in[3] 0.007f
C203 ui_in[1] ui_in[2] 0.10606f
C204 st_2v1_1/a_142_n594# uo_out[1] 0.00466f
C205 r2r_0/a_n1618_n400# st_8v1_0/A 0
C206 uio_in[6] uio_in[7] 0.00747f
C207 VDPWR uo_out[6] 0.00306f
C208 uo_out[1] VDPWR 0.61394f
C209 VDPWR r2r_0/a_1518_400# 0.01128f
C210 uio_in[6] uio_in[5] 0.007f
C211 st_1v1_1/a_142_n38# st_8v1_0/A 0.00325f
C212 st_4v1_0/a_142_n594# uio_in[6] 0.00517f
C213 r2r_0/a_n834_n400# ui_in[4] 0.00102f
C214 VDPWR uio_in[6] 0.59278f
C215 ui_in[3] ui_in[4] 0.10506f
C216 r2r_0/a_1714_n486# ui_in[0] 0
C217 uio_in[6] uio_out[7] 0.07868f
C218 VDPWR ui_in[5] 0.07853f
C219 VDPWR r2r_0/a_342_n400# 0
C220 r2r_0/a_1126_400# VDPWR 0.00107f
C221 r2r_0/a_n1814_n400# VDPWR 0
C222 ui_in[0] r2r_0/a_1714_n400# 0.00639f
C223 VDPWR rst_n 0.00854f
C224 VDPWR r2r_0/a_n246_n486# 0.00209f
C225 ui_in[1] VDPWR 0.10706f
C226 st_2v1_1/a_142_n38# VDPWR 0.00905f
C227 r2r_0/a_n442_n400# VDPWR 0
C228 VDPWR r2r_0/a_1910_n400# 0.00586f
C229 VDPWR r2r_0/a_1518_n400# 0.00519f
C230 uo_out[2] uo_out[3] 0.40465f
C231 r2r_0/a_n1030_n400# ui_in[4] 0.00139f
C232 uio_in[2] uo_out[3] 0.05f
C233 st_4v1_0/a_142_n38# uio_out[5] 0
C234 uio_in[6] uio_out[1] 0
C235 ui_in[7] uo_out[0] 0
C236 VDPWR st_2v1_0/a_142_n38# 0.00247f
C237 uio_out[2] uio_out[3] 0.007f
C238 r2r_0/a_n2206_n400# VDPWR 0
C239 uio_out[3] uio_out[4] 0.007f
C240 ui_in[7] st_8v1_0/A 0.00314f
C241 st_8v1_0/A uo_out[0] 0.11681f
C242 r2r_0/a_n1226_400# ui_in[4] 0
C243 uo_out[3] uio_in[4] 0.04448f
C244 VDPWR uio_out[0] 0.00306f
C245 VDPWR r2r_0/a_n2402_n400# 0
C246 r2r_0/a_n1422_n400# ui_in[5] 0.00231f
C247 st_4v1_0/a_142_n594# uio_out[5] 0
C248 r2r_0/a_n2010_n400# ui_in[6] 0.00273f
C249 VDPWR uio_out[5] 0.13932f
C250 uo_out[1] uo_out[2] 0.34384f
C251 uio_in[2] uo_out[6] 0
C252 VDPWR ui_in[2] 0.08385f
C253 uo_out[1] uio_in[2] 0.04892f
C254 uio_out[7] uio_out[5] 0.01256f
C255 r2r_0/a_n50_400# ui_in[3] 0.00161f
C256 ui_in[2] r2r_0/a_538_n486# 0
C257 uio_in[6] uo_out[2] 0.04841f
C258 uio_in[2] uio_in[6] 0.00198f
C259 uio_in[4] uo_out[6] 0
C260 uo_out[1] uio_in[4] 0.0434f
C261 uio_out[1] uio_out[0] 0.007f
C262 st_4v1_0/a_142_n38# VDPWR 0.01358f
C263 VDPWR uio_in[7] 0.01156f
C264 ui_in[6] r2r_0/a_n2010_400# 0.00274f
C265 uio_in[6] uio_in[4] 1.59166f
C266 st_4v1_1/a_142_n594# uo_out[1] 0.00129f
C267 VDPWR uio_in[5] 0.00306f
C268 ui_in[6] ui_in[5] 0.15013f
C269 ena uio_oe[2] 0.06027f
C270 clk uio_oe[2] 0.05005f
C271 rst_n uio_oe[2] 0.04162f
C272 uio_in[0] uio_oe[2] 0.04155f
C273 uio_in[1] uio_oe[2] 0.04155f
C274 uio_in[3] uio_oe[2] 0.04141f
C275 uio_in[5] uio_oe[2] 0.04147f
C276 uio_in[7] uio_oe[2] 0.04103f
C277 uo_out[4] uio_oe[2] 0.04103f
C278 uo_out[5] uio_oe[2] 0.04103f
C279 uo_out[6] uio_oe[2] 0.04103f
C280 uo_out[7] uio_oe[2] 0.04103f
C281 uio_out[0] uio_oe[2] 0.04103f
C282 uio_out[1] uio_oe[2] 0.04103f
C283 uio_out[2] uio_oe[2] 0.04103f
C284 uio_out[4] uio_oe[2] 0.0412f
C285 uio_out[6] uio_oe[2] 0.04153f
C286 uio_oe[0] uio_oe[2] 0.17515f
C287 uio_oe[1] uio_oe[2] 0.20299f
C288 uio_out[7] uio_oe[2] 0.57265f
C289 VGND uio_oe[2] 1.48357f
C290 uio_oe[6] uio_oe[2] 0.04645f
C291 uio_oe[4] uio_oe[2] 0.01721f
C292 uio_oe[2].n0 uio_oe[2] 8.28054f
C293 uio_oe[2].n1 uio_oe[2] 0.25875f
C294 uio_oe[2].n2 uio_oe[2] 0.27073f
C295 uio_oe[2].n3 uio_oe[2] 0.00643f
C296 uio_oe[2].n4 uio_oe[2] 0.31931f
C297 uio_oe[2].n5 uio_oe[2] 0.01229f
C298 uio_oe[2].n6 uio_oe[2] 0.00593f
C299 uio_oe[2].n7 uio_oe[2] 0.51716f
C300 uio_oe[2].n8 uio_oe[2] 0.007f
C301 uio_oe[2].n9 uio_oe[2] 0.63487f
C302 uio_oe[2].n10 uio_oe[2] 0.12876f
C303 uio_oe[2].n11 uio_oe[2] 0.78369f
C304 uio_oe[2].n12 uio_oe[2] 0.18932f
C305 uio_oe[2].n13 uio_oe[2] 0.27093f
C306 uio_oe[2].n14 uio_oe[2] 0.08237f
C307 uio_oe[2].n15 uio_oe[2] 0.62388f
C308 uio_oe[2].n16 uio_oe[2] 0.83199f
C309 uio_oe[2].n17 uio_oe[2] 0.06625f
C310 uio_oe[2].n18 uio_oe[2] 0.06625f
C311 uio_oe[2].n19 uio_oe[2] 0.01472f
C312 uio_oe[2].n20 uio_oe[2] 0.11603f
C313 uio_oe[2].n21 uio_oe[2] 0.01545f
C314 uio_oe[2].n22 uio_oe[2] 0.38859f
C315 uio_oe[2].n23 uio_oe[2] 0.17249f
C316 uio_oe[2].n24 uio_oe[2] 0.94541f
C317 uio_oe[2].n25 uio_oe[2] 1.92394f
C318 uio_oe[2].n26 uio_oe[2] 0.64899f
C319 uio_oe[2].n27 uio_oe[2] 0.06625f
C320 uio_oe[2].n28 uio_oe[2] 4.46406f
C321 uio_oe[2].n29 uio_oe[2] 0.07489f
C322 uio_oe[2].n30 uio_oe[2] 0.07195f
C323 uio_oe[2].n31 uio_oe[2] 8.30965f
C324 uio_oe[2].n32 uio_oe[2] 0.01301f
C325 uio_oe[2].n33 uio_oe[2] 0.01131f
C326 uio_oe[2].n34 uio_oe[2] 0.18932f
C327 uio_oe[2].n35 uio_oe[2] 0.21489f
C328 uio_oe[2].n36 uio_oe[2] 0.14976f
C329 uio_oe[2].n37 uio_oe[2] 44.6696f
C330 uio_oe[2].n38 uio_oe[2] 0.45012f
C331 uio_oe[2].n39 uio_oe[2] 7.44784f
C332 uio_oe[2].n40 uio_oe[2] 0.02694f
C333 uio_oe[2].n41 uio_oe[2] 0.07225f
C334 uio_oe[2].n42 uio_oe[2] 0.11586f
C335 uio_oe[2].n43 uio_oe[2] 0.08237f
C336 uio_oe[2].n44 uio_oe[2] 0.08237f
C337 uio_oe[2].n45 uio_oe[2] 0.11586f
C338 uio_oe[2].n46 uio_oe[2] 0.11586f
C339 st_8v1_0/a_142_n594# uio_oe[2] 0.00915f
C340 uo_out[3] uio_oe[2] 5.2834f
C341 st_8v1_0/a_142_n38# uio_oe[2] 0.00582f
C342 st_8v1_0/A uio_oe[2] 1.38759f
C343 VDPWR uio_oe[2] 0.12367p
C344 st_2v1_1/a_142_n594# uio_oe[2] 0.00727f
C345 uo_out[1] uio_oe[2] 3.13853f
C346 st_2v1_1/a_142_n38# uio_oe[2] 0.00201f
C347 st_2v1_0/a_142_n594# uio_oe[2] 0.00622f
C348 uio_out[5] uio_oe[2] 0.5906f
C349 st_2v1_0/a_142_n38# uio_oe[2] 0.00239f
C350 uio_in[4] uio_oe[2] 1.74171f
C351 r2r_0/a_2498_n400# uio_oe[2] 0.00304f
C352 r2r_0/a_2106_n486# uio_oe[2] 0
C353 r2r_0/a_1714_n486# uio_oe[2] 0
C354 ui_in[0] uio_oe[2] 0.53903f
C355 ui_in[1] uio_oe[2] 0.44735f
C356 r2r_0/a_930_n486# uio_oe[2] 0
C357 r2r_0/a_538_n486# uio_oe[2] 0
C358 ui_in[2] uio_oe[2] 0.50937f
C359 ui_in[3] uio_oe[2] 0.568f
C360 r2r_0/a_n246_n486# uio_oe[2] 0
C361 r2r_0/a_n638_n486# uio_oe[2] 0
C362 ui_in[4] uio_oe[2] 0.60041f
C363 ui_in[5] uio_oe[2] 0.62061f
C364 r2r_0/a_n1422_n486# uio_oe[2] 0
C365 r2r_0/a_n1814_n486# uio_oe[2] 0
C366 ui_in[6] uio_oe[2] 0.631f
C367 ui_in[7] uio_oe[2] 0.92783f
C368 st_4v1_1/a_142_n594# uio_oe[2] 0.00854f
C369 uo_out[2] uio_oe[2] 3.55663f
C370 st_4v1_1/a_142_n38# uio_oe[2] 0.00328f
C371 st_4v1_0/a_142_n594# uio_oe[2] 0.00248f
C372 uio_in[6] uio_oe[2] 3.29386f
C373 st_1v1_1/a_142_n594# uio_oe[2] 0.00194f
C374 uo_out[0] uio_oe[2] 3.3556f
C375 st_1v1_0/a_142_n594# uio_oe[2] 0
C376 uio_out[3] uio_oe[2] 0.38776f
C377 uio_in[2] uio_oe[2] 3.2443f
.ends
