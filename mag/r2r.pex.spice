* NGSPICE file created from r2r.ext - technology: ihp-sg13g2

.subckt r2r_pex Vb3 Vb1 Vb2 Vb0 Vb4 Vb5 Vb6 Vb7 Vout VSS
X0 a_n2010_400# Vout B.t5 rhigh l=4u w=0.5u
X1 a_n1226_400# Vb5 B.t9 rhigh l=4u w=0.5u
X2 a_1126_400# Vb1 B.t13 rhigh l=4u w=0.5u
X3 a_n2402_400# Vb7 B.t6 rhigh l=4u w=0.5u
X4 B.t1 a_2106_n486# B.t0 rhigh l=4u w=0.5u
X5 a_n50_400# Vb3 B rhigh l=4u w=0.5u
X6 a_n834_400# a_n1422_n486# B.t12 rhigh l=4u w=0.5u
X7 a_342_400# a_538_n486# B.t17 rhigh l=4u w=0.5u
X8 a_n834_400# a_n638_n486# B.t16 rhigh l=4u w=0.5u
X9 Vb6 a_n1814_n486# B.t7 rhigh l=4u w=0.5u
X10 Vb0 a_1714_n486# B.t24 rhigh l=4u w=0.5u
X11 a_342_400# a_n246_n486# B.t18 rhigh l=4u w=0.5u
X12 a_n1226_400# a_n1422_n486# B.t15 rhigh l=4u w=0.5u
X13 a_n2402_400# Vout B.t8 rhigh l=4u w=0.5u
X14 a_1518_400# a_2106_n486# B.t19 rhigh l=4u w=0.5u
X15 a_n2010_400# a_n1422_n486# B.t10 rhigh l=4u w=0.5u
X16 a_1126_400# a_930_n486# B.t23 rhigh l=4u w=0.5u
X17 B.t3 B.t3 B.t2 rhigh l=4u w=0.5u
X18 B.t1 B.t1 B.t4 rhigh l=4u w=0.5u
X19 Vb4 a_n638_n486# B.t26 rhigh l=4u w=0.5u
X20 Vb2 a_538_n486# B.t14 rhigh l=4u w=0.5u
X21 a_342_400# a_930_n486# B.t22 rhigh l=4u w=0.5u
X22 a_n834_400# a_n246_n486# B.t25 rhigh l=4u w=0.5u
X23 a_n2010_400# a_n1814_n486# B.t11 rhigh l=4u w=0.5u
X24 a_1518_400# a_930_n486# B.t20 rhigh l=4u w=0.5u
X25 a_n50_400# a_n246_n486# B.t27 rhigh l=4u w=0.5u
X26 a_1518_400# a_1714_n486# B.t21 rhigh l=4u w=0.5u
R0 B.t6 B.t2 426.087
R1 B.t8 B.t6 426.087
R2 B.t5 B.t8 426.087
R3 B.t7 B.t5 426.087
R4 B.t11 B.t7 426.087
R5 B.t10 B.t11 426.087
R6 B.t9 B.t10 426.087
R7 B.t15 B.t9 426.087
R8 B.t12 B.t15 426.087
R9 B.t26 B.t12 426.087
R10 B.t16 B.t26 426.087
R11 B.t25 B.t16 426.087
R12 B B.t25 426.087
R13 B.t27 B 426.087
R14 B.t18 B.t27 426.087
R15 B.t14 B.t18 426.087
R16 B.t17 B.t14 426.087
R17 B.t22 B.t17 426.087
R18 B.t13 B.t22 426.087
R19 B.t23 B.t13 426.087
R20 B.t20 B.t23 426.087
R21 B.t24 B.t20 426.087
R22 B.t21 B.t24 426.087
R23 B.t19 B.t21 426.087
R24 B.t0 B.t19 426.087
R25 B.t4 B.t0 426.087
R26 B B.t2 353.236
R27 B B.t4 353.236
R28 B B.t1 1.28118
R29 B B.t3 1.18643
C0 a_734_n400# a_342_400# 0.04561f
C1 Vb5 Vb3 0.01692f
C2 a_n638_n486# a_n638_n400# 0.0188f
C3 a_n1422_n486# a_n2010_400# 0.00197f
C4 Vb4 a_n50_400# 0
C5 Vb3 a_n834_n400# 0.00471f
C6 a_930_n400# a_n246_n486# 0
C7 a_n246_n400# a_n50_n400# 0.05097f
C8 a_734_n400# a_930_n400# 0.05097f
C9 a_146_n400# Vb3 0.01859f
C10 a_2106_n486# a_1714_n486# 0.01549f
C11 a_n2402_400# a_n2402_n400# 0.01914f
C12 Vb5 a_n1422_n400# 0.01859f
C13 a_n50_400# a_n834_400# 0.01589f
C14 a_n1422_n486# Vb3 0.00125f
C15 Vb3 a_n246_n486# 0.12443f
C16 a_1910_n400# a_1714_n400# 0.05097f
C17 a_1518_400# a_1714_n400# 0.05016f
C18 Vb1 a_342_n400# 0.00471f
C19 a_n442_n400# a_n638_n486# 0.0188f
C20 a_734_n400# Vb3 0.00471f
C21 a_1518_n400# a_930_n486# 0.0245f
C22 a_538_n486# Vb1 0.00279f
C23 Vb7 a_n1814_n400# 0.00775f
C24 a_n1030_n400# a_n2010_400# 0
C25 Vb6 a_n2010_400# 0.07821f
C26 Vb5 a_n246_n400# 0.0032f
C27 Vb7 a_n2206_n400# 0.02128f
C28 a_n2598_n400# a_n2402_n400# 0.05097f
C29 a_n1226_400# a_n1226_n400# 0.0188f
C30 Vb7 a_n1814_n486# 0
C31 a_n1422_n486# a_n1422_n400# 0.04482f
C32 Vb4 a_n834_400# 0.07821f
C33 a_1714_n486# Vb0 0
C34 a_n2010_400# a_n2010_n400# 0.04482f
C35 a_1518_400# a_1322_n400# 0.00569f
C36 a_n1030_n400# Vb3 0.0032f
C37 a_n1814_n486# a_n1814_n400# 0.0188f
C38 Vb1 a_2106_n400# 0.00366f
C39 a_1910_n400# Vb1 0.00471f
C40 a_342_400# a_930_n400# 0.0245f
C41 a_1518_400# Vb1 0.00625f
C42 a_n1422_n486# a_n246_n400# 0
C43 a_n246_n486# a_n246_n400# 0.04482f
C44 a_n834_400# a_342_n400# 0
C45 a_342_400# Vb3 0.00625f
C46 a_n1226_400# Vb5 0.04014f
C47 Vb1 a_2498_n400# 0
C48 a_342_400# Vb2 0.07821f
C49 a_342_400# a_1126_n400# 0.0016f
C50 a_n2402_400# Vb5 0
C51 a_1714_n400# a_930_n486# 0.0016f
C52 Vb4 a_n638_n400# 0.01501f
C53 a_1322_n400# a_1126_400# 0.0188f
C54 Vb3 a_930_n400# 0.0032f
C55 a_n834_400# a_n638_n400# 0.05016f
C56 a_1126_n400# a_930_n400# 0.05097f
C57 Vb5 a_n638_n486# 0.00146f
C58 Vb1 a_1126_400# 0.04014f
C59 a_n1226_400# a_n1422_n486# 0.00606f
C60 Vb5 Vout 0.00252f
C61 Vb7 a_n1618_n400# 0.00471f
C62 a_n2010_400# a_n1422_n400# 0.0245f
C63 Vb3 Vb2 0.01204f
C64 Vb3 a_1126_n400# 0
C65 Vb7 a_n2402_n400# 0.06729f
C66 a_930_n486# a_1322_n400# 0.04561f
C67 Vb1 a_538_n400# 0.00775f
C68 a_n1814_n400# a_n1618_n400# 0.05097f
C69 a_342_400# a_n246_n400# 0
C70 Vb1 a_930_n486# 0.12443f
C71 a_n442_n400# a_n834_400# 0.04561f
C72 a_n638_n486# a_n1422_n486# 0.01589f
C73 Vb1 a_n50_n400# 0
C74 a_n834_400# a_n1618_n400# 0
C75 a_n638_n486# a_n246_n486# 0.01678f
C76 a_n1422_n486# Vout 0
C77 a_n50_400# a_n50_n400# 0.0188f
C78 a_n1814_n486# a_n1618_n400# 0.0188f
C79 a_n2598_n400# a_n1422_n486# 0
C80 a_n1030_n400# a_n1226_400# 0.0188f
C81 a_342_400# a_1518_n400# 0
C82 a_n2402_n400# a_n2206_n400# 0.05097f
C83 a_n1226_400# Vb6 0
C84 Vb7 a_n1226_n400# 0
C85 a_n2402_400# Vb6 0.00206f
C86 Vb3 a_n246_n400# 0.01859f
C87 a_2302_n400# Vb1 0.00263f
C88 a_1910_n400# a_2106_n400# 0.05097f
C89 a_1518_400# a_2106_n400# 0.02482f
C90 a_1518_400# a_1910_n400# 0.04561f
C91 Vb5 a_n50_400# 0
C92 a_n442_n400# a_n638_n400# 0.05097f
C93 a_n834_400# a_n1226_n400# 0.0016f
C94 a_n1226_400# a_n2010_400# 0.01589f
C95 a_1518_400# a_2498_n400# 0
C96 a_n834_400# a_n50_n400# 0.0016f
C97 a_342_n400# a_538_n400# 0.05097f
C98 a_146_n400# Vb1 0.0032f
C99 a_n2402_400# a_n2010_400# 0.01678f
C100 a_538_n486# a_538_n400# 0.0188f
C101 Vout a_n2010_n400# 0.0301f
C102 Vb5 Vb7 0.01536f
C103 a_342_n400# a_930_n486# 0
C104 a_146_n400# a_n50_400# 0.0188f
C105 a_538_n486# a_930_n486# 0.01678f
C106 Vb1 a_n246_n486# 0.00125f
C107 a_1714_n400# Vb0 0.01501f
C108 a_734_n400# Vb1 0.01204f
C109 Vb5 Vb4 0.01204f
C110 a_n1226_400# Vb3 0
C111 a_n50_400# a_n246_n486# 0.00606f
C112 a_2106_n486# Vb1 0
C113 Vb5 a_n1814_n400# 0.00775f
C114 a_n2010_400# Vout 0.00268f
C115 a_1518_400# a_1126_400# 0.01678f
C116 Vb5 a_n834_400# 0.00625f
C117 a_n2598_n400# a_n2010_400# 0
C118 a_n1422_n486# Vb7 0
C119 Vb5 a_n2206_n400# 0.00366f
C120 Vb5 a_n1814_n486# 0.00279f
C121 a_n638_n486# Vb3 0.00279f
C122 a_n834_n400# a_n834_400# 0.04482f
C123 a_1714_n486# a_1714_n400# 0.0188f
C124 a_930_n486# a_2106_n400# 0
C125 a_1910_n400# a_930_n486# 0
C126 a_1518_400# a_930_n486# 0.00197f
C127 a_146_n400# a_n834_400# 0
C128 a_n1422_n486# a_n1814_n400# 0.0016f
C129 Vb1 Vb0 0.01204f
C130 a_342_400# a_1322_n400# 0
C131 a_n1422_n486# a_n834_400# 0.00197f
C132 a_n834_400# a_n246_n486# 0.00197f
C133 a_146_n400# a_342_n400# 0.05097f
C134 a_n1422_n486# a_n2206_n400# 0
C135 a_n1422_n486# a_n1814_n486# 0.01678f
C136 a_2498_n400# a_930_n486# 0
C137 a_342_400# Vb1 0.01184f
C138 a_342_n400# a_n246_n486# 0.0245f
C139 Vb5 a_n638_n400# 0.00775f
C140 a_538_n486# a_n246_n486# 0.01589f
C141 a_342_400# a_n50_400# 0.01678f
C142 Vb7 Vb6 0.01204f
C143 a_2302_n400# a_2106_n400# 0.05097f
C144 a_734_n400# a_538_n486# 0.0188f
C145 a_2302_n400# a_1518_400# 0.0016f
C146 Vb7 a_n2010_n400# 0.01204f
C147 a_n834_n400# a_n638_n400# 0.05097f
C148 a_1714_n486# Vb1 0.00146f
C149 Vb1 a_930_n400# 0.01859f
C150 Vb6 a_n1814_n400# 0.01501f
C151 a_930_n486# a_1126_400# 0.00606f
C152 a_n1030_n400# a_n834_400# 0.00569f
C153 a_1126_n400# a_1322_n400# 0.05097f
C154 a_2302_n400# a_2498_n400# 0.05097f
C155 a_n1814_n400# a_n2010_n400# 0.05097f
C156 a_n1422_n486# a_n638_n400# 0.0016f
C157 Vb3 Vb1 0.01692f
C158 a_n442_n400# Vb5 0.00471f
C159 a_n638_n400# a_n246_n486# 0.0016f
C160 Vb5 a_n1618_n400# 0.01204f
C161 a_n1814_n486# Vb6 0
C162 Vb7 a_n2010_400# 0.00625f
C163 Vb1 Vb2 0.01204f
C164 Vb1 a_1126_n400# 0.0496f
C165 a_930_n486# a_538_n400# 0.0016f
C166 Vb3 a_n50_400# 0.04014f
C167 Vb5 a_n2402_n400# 0
C168 a_n50_400# Vb2 0.00206f
C169 a_n2206_n400# a_n2010_n400# 0.05097f
C170 a_342_400# a_n834_400# 0.00278f
C171 a_734_n400# a_1518_400# 0
C172 a_2106_n486# a_2106_n400# 0.01914f
C173 a_n1814_n400# a_n2010_400# 0.05016f
C174 a_2106_n486# a_1518_400# 0.00171f
C175 a_n834_400# a_n2010_400# 0.00278f
C176 a_342_400# a_342_n400# 0.04482f
C177 a_1518_n400# a_1714_n400# 0.05097f
C178 a_538_n486# a_342_400# 0.00606f
C179 a_n442_n400# a_n1422_n486# 0
C180 a_n442_n400# a_n246_n486# 0.00569f
C181 a_n1422_n486# a_n1618_n400# 0.00569f
C182 a_n2206_n400# a_n2010_400# 0.00569f
C183 a_n1814_n486# a_n2010_400# 0.00606f
C184 Vb3 Vb4 0.01204f
C185 a_n1422_n486# a_n2402_n400# 0
C186 a_n2402_400# Vout 0.00205f
C187 a_2302_n400# a_930_n486# 0
C188 Vb5 a_n1226_n400# 0.0496f
C189 Vb3 a_n834_400# 0.01184f
C190 Vb5 a_n50_n400# 0
C191 Vb7 a_n1422_n400# 0.0032f
C192 a_1518_400# Vb0 0.07821f
C193 a_1518_n400# a_1322_n400# 0.05097f
C194 a_n638_n486# Vout 0
C195 Vb3 a_342_n400# 0.01204f
C196 a_538_n486# Vb3 0.00146f
C197 a_342_400# a_1518_400# 0.00278f
C198 a_1518_n400# Vb1 0.01204f
C199 a_538_n486# Vb2 0
C200 a_146_n400# a_930_n486# 0
C201 a_n246_n486# a_538_n400# 0.0016f
C202 a_146_n400# a_n50_n400# 0.05097f
C203 a_n834_400# a_n1422_n400# 0
C204 a_n1422_n486# a_n1226_n400# 0.05016f
C205 a_734_n400# a_538_n400# 0.05097f
C206 a_930_n486# a_n246_n486# 0.00278f
C207 a_n246_n486# a_n50_n400# 0.05016f
C208 a_734_n400# a_930_n486# 0.00569f
C209 a_1714_n486# a_1910_n400# 0.0188f
C210 a_1714_n486# a_1518_400# 0.00606f
C211 a_2106_n486# a_930_n486# 0
C212 a_342_400# a_n442_n400# 0
C213 a_1518_400# a_930_n400# 0
C214 Vb3 a_n638_n400# 0.00775f
C215 Vb5 a_n834_n400# 0.01204f
C216 Vb0 a_1126_400# 0.00206f
C217 a_n834_400# a_n246_n400# 0.0245f
C218 a_n2010_400# a_n1618_n400# 0.04561f
C219 a_1518_400# a_1126_n400# 0.0016f
C220 a_n2402_n400# a_n2010_400# 0.0016f
C221 Vb5 a_n1422_n486# 0.12443f
C222 a_n1030_n400# a_n1226_n400# 0.05097f
C223 a_342_400# a_1126_400# 0.01589f
C224 Vb5 a_n246_n486# 0
C225 a_n1226_400# Vb7 0
C226 a_2302_n400# a_2106_n486# 0.01914f
C227 a_n2402_400# Vb7 0.04212f
C228 a_n442_n400# Vb3 0.01204f
C229 a_n1422_n486# a_n834_n400# 0.0245f
C230 a_n1226_400# Vb4 0.00206f
C231 a_n834_n400# a_n246_n486# 0
C232 a_342_400# a_538_n400# 0.05016f
C233 a_146_n400# a_n246_n486# 0.04561f
C234 Vb1 a_1714_n400# 0.00775f
C235 a_342_400# a_930_n486# 0.00197f
C236 a_n1226_400# a_n834_400# 0.01678f
C237 a_342_400# a_n50_n400# 0.0016f
C238 a_n1422_n486# a_n246_n486# 0.00278f
C239 Vb7 Vout 0.03276f
C240 a_n2010_400# a_n1226_n400# 0.0016f
C241 Vb3 a_1126_400# 0
C242 a_734_n400# a_n246_n486# 0
C243 a_n1030_n400# Vb5 0.01859f
C244 a_n2598_n400# Vb7 0
C245 Vb5 Vb6 0.01204f
C246 a_n1422_n400# a_n1618_n400# 0.05097f
C247 Vb2 a_1126_400# 0
C248 a_1126_n400# a_1126_400# 0.0188f
C249 a_n638_n486# Vb4 0
C250 a_n2402_400# a_n2206_n400# 0.01914f
C251 a_1714_n486# a_930_n486# 0.01589f
C252 a_930_n486# a_930_n400# 0.04482f
C253 Vb5 a_n2010_n400# 0.00471f
C254 a_n1030_n400# a_n834_n400# 0.05097f
C255 Vb3 a_538_n400# 0.00775f
C256 Vb1 a_1322_n400# 0.01859f
C257 a_n638_n486# a_n834_400# 0.00606f
C258 Vb2 a_538_n400# 0.01501f
C259 Vb3 a_n1226_n400# 0
C260 Vb3 a_930_n486# 0
C261 a_1518_400# a_1518_n400# 0.04482f
C262 a_n442_n400# a_n246_n400# 0.05097f
C263 Vb3 a_n50_n400# 0.0496f
C264 a_n2206_n400# Vout 0.03107f
C265 a_1126_n400# a_930_n486# 0.05016f
C266 a_n1814_n486# Vout 0.02235f
C267 a_n1030_n400# a_n1422_n486# 0.04561f
C268 a_n1030_n400# a_n246_n486# 0
C269 a_n50_400# Vb1 0
C270 Vb5 a_n2010_400# 0.01184f
C271 a_342_400# a_146_n400# 0.00569f
C272 a_n1422_n486# a_n2010_n400# 0
C273 a_n1226_n400# a_n1422_n400# 0.05097f
C274 a_n834_n400# a_n2010_400# 0
C275 a_342_400# a_n246_n486# 0.00197f
C276 a_2106_n486# B 0.59545f
C277 a_1714_n486# B 0.53953f
C278 Vb0 B 0.36617f
C279 a_1518_400# B 0.9199f
C280 Vb1 B 0.50091f
C281 a_1126_400# B 0.53659f
C282 a_930_n486# B 0.89529f
C283 a_538_n486# B 0.53579f
C284 Vb2 B 0.34078f
C285 a_342_400# B 0.89137f
C286 Vb3 B 0.46013f
C287 a_n50_400# B 0.53579f
C288 a_n246_n486# B 0.89111f
C289 a_n638_n486# B 0.53579f
C290 Vb4 B 0.34078f
C291 a_n834_400# B 0.89111f
C292 Vb5 B 0.46087f
C293 a_n1226_400# B 0.53638f
C294 a_n1422_n486# B 0.89446f
C295 a_n1814_n486# B 0.53795f
C296 Vb6 B 0.34245f
C297 a_n2010_400# B 0.89767f
C298 Vout B 0.70446f
C299 Vb7 B 0.71021f
C300 a_n2402_400# B 0.5834f
C301 B.t1 B 0.83386f
C302 B.t3 B 0.63443f
.ends
