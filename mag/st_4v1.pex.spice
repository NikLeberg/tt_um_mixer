* NGSPICE file created from st_4v1.ext - technology: ihp-sg13g2

.subckt st_4v1_pex VDD A Y VSS
X0 a_142_n38# Y VSS.t0 VDD sg13_lv_pmos ad=0.204p pd=1.88u as=0.204p ps=1.88u w=0.6u l=0.13u
X1 Y A a_142_n38# VDD sg13_lv_pmos ad=0.816p pd=5.48u as=0.456p ps=2.78u w=2.4u l=0.13u
X2 VDD Y a_142_n594# VSS.t1 sg13_lv_nmos ad=0.204p pd=1.88u as=0.204p ps=1.88u w=0.6u l=0.13u
X3 a_142_n594# A VSS.t3 VSS.t2 sg13_lv_nmos ad=0.456p pd=2.78u as=0.816p ps=5.48u w=2.4u l=0.13u
X4 a_142_n38# A VDD VDD sg13_lv_pmos ad=0.456p pd=2.78u as=0.816p ps=5.48u w=2.4u l=0.13u
X5 Y A a_142_n594# VSS.t4 sg13_lv_nmos ad=0.816p pd=5.48u as=0.456p ps=2.78u w=2.4u l=0.13u
R0 VSS.n2 VSS.t2 437.858
R1 VSS.t2 VSS.t1 139.734
R2 VSS.t1 VSS.t4 6.23253
R3 VSS.n0 VSS.n2 0.160371
R4 VSS.n1 VSS.t3 2.42907
R5 VSS.n0 VSS.t0 1.54961
R6 VSS.n2 VSS.t4 1.59093
R7 VSS.n0 VSS.n1 0.880425
R8 VSS VSS.n1 1.14251
R9 VSS VSS.t0 1.01184
C0 VDD a_142_n594# 0.04956f
C1 Y a_142_n594# 0.22595f
C2 A a_142_n594# 0.10157f
C3 Y VDD 0.4171f
C4 a_142_n38# VDD 0.19842f
C5 a_142_n38# Y 0.22595f
C6 A VDD 0.71695f
C7 A Y 0.11155f
C8 A a_142_n38# 0.10157f
C9 a_142_n594# VSS 0.49316f
C10 a_142_n38# VSS 0.98126f
C11 VDD VSS 0.96705f
C12 VSS.t0 VSS 0.34052f
.ends
